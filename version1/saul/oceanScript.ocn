simulator( 'spectre )
design(	 "/home/saul/Sim/NOISE/spectre/schematic/netlist/netlist")
resultsDir( "/home/saul/Sim/NOISE/spectre/schematic" )
modelFile(
    '("/pkg/AMS/spectre/h18/soac/mcparams.scs" "")
    '("/pkg/AMS/spectre/h18/soac/design.scs" "noitm")
    '("/pkg/AMS/spectre/h18/soac/res.scs" "restm")
    '("/pkg/AMS/spectre/h18/soac/cap.scs" "captm")
    '("/pkg/AMS/spectre/h18/soac/bip.scs" "biptm")
    '("/pkg/AMS/spectre/h18/soac/esddi.scs" "esdditm")
    '("/pkg/AMS/spectre/h18/soac/cmos53.scs" "cmostm")
)
analysis('ac ?start "1"  ?stop "10k"  ?step "12"  )
envOption(
	'analysisOrder  list("ac")
)
temp( 27 )
run()
selectResult( 'ac )
plot(getData("/VOUT") )
