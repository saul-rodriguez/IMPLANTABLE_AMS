simulator( 'spectre )
design(	 "/home/saul/Sim/s1/spectre/schematic/netlist/netlist")
resultsDir( "/home/saul/Sim/s1/spectre/schematic" )
modelFile(
    '("/pkg/AMS/spectre/h18/soac/mcparams.scs" "")
    '("/pkg/AMS/spectre/h18/soac/design.scs" "noitm")
    '("/pkg/AMS/spectre/h18/soac/res.scs" "restm")
    '("/pkg/AMS/spectre/h18/soac/cap.scs" "captm")
    '("/pkg/AMS/spectre/h18/soac/bip.scs" "biptm")
    '("/pkg/AMS/spectre/h18/soac/esddi.scs" "esdditm")
    '("/pkg/AMS/spectre/h18/soac/cmos53.scs" "cmostm")
)
analysis('ac ?start "0.1"  ?stop "1G"  ?dec "10"  )
analysis('pz ?p "/VOUTP"  ?n "/VOUTN"  ?iprobe "/I6"  )
desVar(	  "cdb1" 1	)
desVar(	  "cdb4" 1	)
desVar(	  "cdg1" 1	)
desVar(	  "cdg4" 1	)
desVar(	  "cds1" 1	)
desVar(	  "cds4" 1	)
desVar(	  "cgs1" 1	)
desVar(	  "cgs4" 1	)
desVar(	  "CL" 1	)
desVar(	  "gm1" 1	)
desVar(	  "gm4" 1	)
desVar(	  "IN" 1	)
desVar(	  "R1" 1	)
desVar(	  "rd1" 1	)
desVar(	  "rd4" 1	)
desVar(	  "RS" 1	)
envOption(
	'analysisOrder  list("ac" "pz")
)
temp( 27 )
run()
selectResult( 'ac )
plot(getData("/VOUTP") getData("/VOUTN") )
