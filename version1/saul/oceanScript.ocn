simulator( 'spectre )
design(	 "/afs/kth.se/home/s/a/saul/Sim/s1/spectre/schematic/netlist/netlist")
resultsDir( "/afs/kth.se/home/s/a/saul/Sim/s1/spectre/schematic" )
modelFile(
    '("/afs/ict.kth.se/proj/ektlab/PDK/AMS/spectre/h18/soac/mcparams.scs" "")
    '("/afs/ict.kth.se/proj/ektlab/PDK/AMS/spectre/h18/soac/design.scs" "noitm")
    '("/afs/ict.kth.se/proj/ektlab/PDK/AMS/spectre/h18/soac/res.scs" "restm")
    '("/afs/ict.kth.se/proj/ektlab/PDK/AMS/spectre/h18/soac/cap.scs" "captm")
    '("/afs/ict.kth.se/proj/ektlab/PDK/AMS/spectre/h18/soac/bip.scs" "biptm")
    '("/afs/ict.kth.se/proj/ektlab/PDK/AMS/spectre/h18/soac/esddi.scs" "esdditm")
    '("/afs/ict.kth.se/proj/ektlab/PDK/AMS/spectre/h18/soac/cmos53.scs" "cmostm")
)
analysis('ac ?start "1"  ?stop "10"  )
envOption(
	'analysisOrder  list("ac")
)
temp( 27 )
run()
selectResult( 'ac )
plot(getData("/VB") getData("/VA") getData("/VOUT") )
