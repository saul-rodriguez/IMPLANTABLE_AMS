simulator( 'spectre )
design(	 "/afs/kth.se/home/s/a/saul/Sim/S2/spectre/schematic/netlist/netlist")
resultsDir( "/afs/kth.se/home/s/a/saul/Sim/S2/spectre/schematic" )
modelFile(
    '("/afs/ict.kth.se/proj/ektlab/PDK/AMS/spectre/h18/soac/mcparams.scs" "")
    '("/afs/ict.kth.se/proj/ektlab/PDK/AMS/spectre/h18/soac/design.scs" "noitm")
    '("/afs/ict.kth.se/proj/ektlab/PDK/AMS/spectre/h18/soac/res.scs" "restm")
    '("/afs/ict.kth.se/proj/ektlab/PDK/AMS/spectre/h18/soac/cap.scs" "captm")
    '("/afs/ict.kth.se/proj/ektlab/PDK/AMS/spectre/h18/soac/bip.scs" "biptm")
    '("/afs/ict.kth.se/proj/ektlab/PDK/AMS/spectre/h18/soac/esddi.scs" "esdditm")
    '("/afs/ict.kth.se/proj/ektlab/PDK/AMS/spectre/h18/soac/cmos53.scs" "cmostm")
)
analysis('ac ?start "0.01"  ?stop "1000M"  ?dec "10"  )
analysis('dc ?saveOppoint t  )
desVar(	  "DC_IN" 0	)
desVar(	  "VDC_CM" 0.9	)
desVar(	  "VIN_AC" 1	)
desVar(	  "VIN_PULSE" 0	)
envOption(
	'analysisOrder  list("dc" "ac")
)
option( ?categ 'turboOpts
	'uniMode  "APS"
)
save( 'i "/TP1/D" "/R2/PLUS" "/R1/PLUS" )
temp( 27 )
run()
selectResult( 'dcOp )
plot(getData("/TP1/D") getData("/R2/PLUS") getData("/R1/PLUS") )
selectResult( 'ac )
plot(getData("/TP1/D") getData("/R2/PLUS") getData("/R1/PLUS") )
phase_int = phaseDeg(i("/TP1/D" ?result "ac"))
plot( phase_int ?expr '( "phase_int" ) )
phase_res = phaseDeg(i("/R2/PLUS" ?result "ac"))
plot( phase_res ?expr '( "phase_res" ) )
