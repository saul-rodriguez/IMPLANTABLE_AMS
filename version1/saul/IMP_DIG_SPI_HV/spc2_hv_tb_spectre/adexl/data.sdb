ADE simulation setup
Run mode: Single Run, Sweeps and Corners
Tests:
  IMP_DIG_SPI_HV:spc2_hv_tb_spectre:1: IMP_DIG_SPI_HV/spc2_hv_tb_spectre/config, simulator spectre
