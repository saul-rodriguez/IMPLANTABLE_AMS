ADE simulation setup
Run mode: Single Run, Sweeps and Corners
Tests:
  IMP_DIG_SPI_HV:spc2_hv_tb:1: IMP_DIG_SPI_HV/spc2_hv_tb/config, simulator ams
