ADE simulation setup
Run mode: Single Run, Sweeps and Corners
Tests:
  CHARACTERIZATION:FT:1: CHARACTERIZATION/FT/schematic, simulator spectre
Global variables:
  W = 10u
  L = 180n
  VDS = 1
  IDC = {Inclusion List}1m{Inclusion List}{From/To}Decade:1u:10:10m{From/To}
