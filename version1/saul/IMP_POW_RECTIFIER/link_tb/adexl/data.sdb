ADE simulation setup
Run mode: Monte Carlo Sampling
Tests:
  IMP_POW_RECTIFIER:link_tb:1: IMP_POW_RECTIFIER/link_tb/schematic, simulator spectre
Global variables:
  freq_TX = 10M
  CL = 10n
  coup = 5m
  DEL = 30u
  RL = 10k
  RX_DATA_PULSE = 0
  TX_DATA_PULSE = 5
  TXDATA = 0
Corners (all switched off):
  model folders: $AMS_DIR/spectre/h18/soac
  every corner: $AMS_DIR/spectre/h18/soac/design.scs[noitm], $AMS_DIR/spectre/h18/soac/esddi.scs[esdditm], $AMS_DIR/spectre/h18/soac/bip.scs[biptm]
  corner_0: temperature=27; cap.scs[capwp], res.scs[reswp], cmos53.scs[cmosfff]
  corner_1: temperature=27; cap.scs[capws], res.scs[reswp], cmos53.scs[cmosfff]
  corner_2: temperature=27; cap.scs[capwp], res.scs[resws], cmos53.scs[cmosfff]
  corner_3: temperature=27; cap.scs[capws], res.scs[resws], cmos53.scs[cmosfff]
  corner_4: temperature=27; cap.scs[capwp], res.scs[reswp], cmos53.scs[cmosssf]
  corner_5: temperature=27; cap.scs[capws], res.scs[reswp], cmos53.scs[cmosssf]
  corner_6: temperature=27; cap.scs[capwp], res.scs[resws], cmos53.scs[cmosssf]
  corner_7: temperature=27; cap.scs[capws], res.scs[resws], cmos53.scs[cmosssf]
  corner_8: temperature=27; cap.scs[capwp], res.scs[reswp], cmos53.scs[cmoswo]
  corner_9: temperature=27; cap.scs[capws], res.scs[reswp], cmos53.scs[cmoswo]
  corner_10: temperature=27; cap.scs[capwp], res.scs[resws], cmos53.scs[cmoswo]
  corner_11: temperature=27; cap.scs[capws], res.scs[resws], cmos53.scs[cmoswo]
  corner_12: temperature=27; cap.scs[capwp], res.scs[reswp], cmos53.scs[cmoswz]
  corner_13: temperature=27; cap.scs[capws], res.scs[reswp], cmos53.scs[cmoswz]
  corner_14: temperature=27; cap.scs[capwp], res.scs[resws], cmos53.scs[cmoswz]
  corner_15: temperature=27; cap.scs[capws], res.scs[resws], cmos53.scs[cmoswz]
Monte Carlo Sampling options: mcmethod=all, mcnumpoints=100
