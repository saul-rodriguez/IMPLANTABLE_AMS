ADE simulation setup
Run mode: Single Run, Sweeps and Corners
Tests:
  IMP_AN_DIFTOSE:dif2se_tb:1 (off): IMP_AN_DIFTOSE/dif2se_tb/config, simulator spectre
    Outputs: VDC("/VOUT"); dB20(VF("/VOUT"))
  IMP_AN_DIFTOSE:dif2se_tb:1:1: IMP_AN_DIFTOSE/dif2se_tb/config, simulator ams
    Outputs: VDC("/VOUT"); dB20(VF("/VOUT"))
Global variables:
  VAC = 1
  VAC_CM = 0
  VCM = 900m
  VDC = 0
  VCM_PULSE = 0
  VIN_PULSE = 10m
  CC = 2p
  RC = 33k
  BONDWIRE = 3n
  VCLOCK = 0
  CFIL = 10p
Corners (all switched off):
  model folders: /pkg/AMS411/spectre/h18
  every corner: /pkg/AMS411/spectre/h18/mcparams.scs, /pkg/AMS411/spectre/h18/design.scs[noitm], /pkg/AMS411/spectre/h18/bip.scs[biptm], /pkg/AMS411/spectre/h18/esddi.scs[esdditm]
  C0_0: res.scs[reswp], cap.scs[capwp], cmos53.scs[cmosfff]
  C0_1: res.scs[resws], cap.scs[capwp], cmos53.scs[cmosfff]
  C0_2: res.scs[reswp], cap.scs[capws], cmos53.scs[cmosfff]
  C0_3: res.scs[resws], cap.scs[capws], cmos53.scs[cmosfff]
  C0_4: res.scs[reswp], cap.scs[capwp], cmos53.scs[cmosssf]
  C0_5: res.scs[resws], cap.scs[capwp], cmos53.scs[cmosssf]
  C0_6: res.scs[reswp], cap.scs[capws], cmos53.scs[cmosssf]
  C0_7: res.scs[resws], cap.scs[capws], cmos53.scs[cmosssf]
  C0_8: res.scs[reswp], cap.scs[capwp], cmos53.scs[cmoswo]
  C0_9: res.scs[resws], cap.scs[capwp], cmos53.scs[cmoswo]
  C0_10: res.scs[reswp], cap.scs[capws], cmos53.scs[cmoswo]
  C0_11: res.scs[resws], cap.scs[capws], cmos53.scs[cmoswo]
  C0_12: res.scs[reswp], cap.scs[capwp], cmos53.scs[cmoswz]
  C0_13: res.scs[resws], cap.scs[capwp], cmos53.scs[cmoswz]
  C0_14: res.scs[reswp], cap.scs[capws], cmos53.scs[cmoswz]
  C0_15: res.scs[resws], cap.scs[capws], cmos53.scs[cmoswz]
