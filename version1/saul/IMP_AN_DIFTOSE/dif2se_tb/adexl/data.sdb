ADE simulation setup
Run mode: Single Run, Sweeps and Corners
Tests:
  IMP_AN_DIFTOSE:dif2se_tb:1: IMP_AN_DIFTOSE/dif2se_tb/config, simulator spectre
    Outputs: VDC("/VOUT")
Global variables:
  VAC = 1
  VAC_CM = 0
  VCM = 900m
  VDC = 0
  VCM_PULSE = 0
  VIN_PULSE = 10m
  CC = 2p
  RC = 33k
  BONDWIRE = 3n
  VCLOCK = 0
  CFIL = 10p
