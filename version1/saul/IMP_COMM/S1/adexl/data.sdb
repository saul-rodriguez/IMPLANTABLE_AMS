ADE simulation setup
Run mode: Single Run, Sweeps and Corners
Tests:
  IMP_COMM:S1:1: IMP_COMM/S1/config, simulator ams
Global variables:
  C1 = 47n
  R1 = 500k
  VCOMP = 1.1
  AMPLITUDE = 200m
  VOFFSET = 1.5
