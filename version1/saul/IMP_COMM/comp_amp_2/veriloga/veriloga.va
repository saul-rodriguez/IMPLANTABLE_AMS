// VerilogA for IMP_COMM, comp_amp, veriloga

`include "constants.vams"
`include "disciplines.vams"

module comp_amp(OUT, COMP, N_IN, P_IN, vdda, vssa, vsub, bias_in);
output OUT;
electrical OUT;
inout COMP;
electrical COMP;
inout N_IN;
electrical N_IN;
inout P_IN;
electrical P_IN;
inout vdda;
electrical vdda;
inout vssa;
electrical vssa;
inout vsub;
electrical vsub;
input bias_in;
electrical bias_in;

parameter real gain = 1000.0 ;

parameter real rout = 10.0;
parameter real rin = 100e6;
parameter real iout_max = 10e-6;
parameter real volc = 1;
parameter real voutmax = 1.8;
parameter real voutmin = 0;

real vout, vout0, iout, vin;

analog begin

vout = (V(P_IN) - V(N_IN))*gain;

if (vout > 1.8) begin
	vout = 1.8;
end

if (vout < 0) begin
	vout = 0;
end

V(OUT,vssa) <+ vout;

//I(OUT,vssa) <+ V(OUT)/100e6;
I(P_IN) <+ V(P_IN)/100e6;
I(N_IN) <+ V(N_IN)/100e6;

end

endmodule
