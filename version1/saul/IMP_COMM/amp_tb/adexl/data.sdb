ADE simulation setup
Run mode: Single Run, Sweeps and Corners
Tests:
  IMP_COMM:amp_tb:1: IMP_COMM/amp_tb/config, simulator spectre
Global variables:
  CL = 30p
  IN = 900m
