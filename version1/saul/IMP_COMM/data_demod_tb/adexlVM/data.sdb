ADE simulation setup
Run mode: Single Run, Sweeps and Corners
Tests:
  IMP_COMM:data_demod_tb:1: IMP_COMM/data_demod_tb/config, simulator ams
Global variables:
  AMPLITUDE = 100m
  C1 = 50n
  R1 = 300k
  VCOMP = 980m
  VOFFSET = 1.5
  CL = 10p
Corners (all switched off):
  model folders: /pkg/AMS411/spectre/h18/soac
  every corner: /pkg/AMS411/spectre/h18/soac/mcparams.scs, /pkg/AMS411/spectre/h18/soac/design.scs[noitm], /pkg/AMS411/spectre/h18/soac/bip.scs[biptm], /pkg/AMS411/spectre/h18/soac/esddi.scs[esdditm]
  C0_0: res.scs[reswp], cap.scs[capwp], cmos53.scs[cmosfff]
  C0_1: res.scs[resws], cap.scs[capwp], cmos53.scs[cmosfff]
  C0_2: res.scs[reswp], cap.scs[capws], cmos53.scs[cmosfff]
  C0_3: res.scs[resws], cap.scs[capws], cmos53.scs[cmosfff]
  C0_4: res.scs[reswp], cap.scs[capwp], cmos53.scs[cmosssf]
  C0_5: res.scs[resws], cap.scs[capwp], cmos53.scs[cmosssf]
  C0_6: res.scs[reswp], cap.scs[capws], cmos53.scs[cmosssf]
  C0_7: res.scs[resws], cap.scs[capws], cmos53.scs[cmosssf]
  C0_8: res.scs[reswp], cap.scs[capwp], cmos53.scs[cmoswo]
  C0_9: res.scs[resws], cap.scs[capwp], cmos53.scs[cmoswo]
  C0_10: res.scs[reswp], cap.scs[capws], cmos53.scs[cmoswo]
  C0_11: res.scs[resws], cap.scs[capws], cmos53.scs[cmoswo]
  C0_12: res.scs[reswp], cap.scs[capwp], cmos53.scs[cmoswz]
  C0_13: res.scs[resws], cap.scs[capwp], cmos53.scs[cmoswz]
  C0_14: res.scs[reswp], cap.scs[capws], cmos53.scs[cmoswz]
  C0_15: res.scs[resws], cap.scs[capws], cmos53.scs[cmoswz]
