ADE simulation setup
Run mode: Single Run, Sweeps and Corners
Tests:
  IMP_COMM:data_demod_tb:1: IMP_COMM/data_demod_tb/config, simulator ams
Global variables:
  AMPLITUDE = 100m
  C1 = 50n
  R1 = 500k
  VCOMP = 1.1
  VOFFSET = 1.5
