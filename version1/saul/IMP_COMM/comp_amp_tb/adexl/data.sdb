ADE simulation setup
Run mode: Single Run, Sweeps and Corners
Tests:
  IMP_COMM:comp_amp_tb:1 (off): IMP_COMM/comp_amp_tb/config, simulator spectre
    Outputs: dB20(VF("/OUT")); VT("/OUT"); VS("/OUT"); copy2
  IMP_COMM:comp_amp_tb:1:1: IMP_COMM/comp_amp_tb/config, simulator spectre
    Outputs: dB20(VF("/OUT")); VT("/OUT"); copy1; copy2
Global variables:
  CL = 2p,20p,200p
  IN = 900m
  IN2 = 100n (off)
  VCM_PULSE = 10m
