ADE simulation setup
Run mode: Single Run, Sweeps and Corners
Tests:
  IMP_COMM:comp_amp_tb:1: IMP_COMM/comp_amp_tb/config, simulator spectre
    Outputs: dB20(VF("/OUT"))
Global variables:
  CL = 300p
  IN = 900m
  IN2 = 100n (off)
