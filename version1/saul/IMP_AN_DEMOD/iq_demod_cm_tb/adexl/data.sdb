ADE simulation setup
Run mode: Single Run, Sweeps and Corners
Tests:
  IMP_AN_DEMOD:iq_demod_cm_tb:1: IMP_AN_DEMOD/iq_demod_cm_tb/config, simulator ams
Global variables:
  AMP_IN = 0
  AMP_PHA = 0
  CLOCKWIDTH = 15625
  CLPF = 400p
  CM_AMP = 0
  CM_FREQ = 1M
  CPAD = 100f
  CTIA = 1n
  DC_IN = 0
  FREQ = 1k
  G0 = 1.8
  G0_SG = 1.8
  G1 = 1.8
  G1_SG = 1.8
  G2 = 0
  IQCTRL = 0
  STEPNUM = 0
  VAC_CM = 0
  VCM_PULSE = 0
  VDC_CM = 900m
  VDD_PULSE = 0
  VIN_AC = 0
  VIN_PULSE = 0
  Vsupply = 1.8
  RL = 1k
  CM_AMP_SIN = 300m
