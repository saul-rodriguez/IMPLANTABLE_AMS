ADE simulation setup
Run mode: Single Run, Sweeps and Corners
Tests:
  IMP_AN_DEMOD:iq_demod_tb_pss:1: IMP_AN_DEMOD/iq_demod_tb_pss/config, simulator spectre
Global variables:
  AMP_IN = 10m
  AMP_PHA = 0
  CLPF = 1n
  CM_AMP = 0
  CM_FREQ = 1k
  CMFB_AC = 0
  CMFB_PULSE_TIA = 0
  CPAD = 800f
  CTIA = 4n
  DC_IN = 0
  FREQ = 1k
  G0 = 1.8
  G1 = 1.8
  G2 = 0
  IQCTRL = 0
  VAC_CM = 0
  VCM_PULSE = 0
  VDC_CM = 900m
  VDD_PULSE = 0
  VIN_AC = 0
  VIN_PULSE = 0
  Vsupply = 1.8
