ADE simulation setup
Run mode: Single Run, Sweeps and Corners
Tests:
  IMP_AN_TIA:tia_lpf_lna_tb:1: IMP_AN_TIA/tia_lpf_lna_tb/config, simulator ams
    Outputs: GAINF; PHASE_LNA; OUTL_TRAN; OUT_TIA
Global variables:
  CEXT = 4.7n
  CMFB_AC = 0
  CMFB_PULSE = 0
  CMFB_VAC = 0
  CPAD = 0
  DC_IN = 0
  G0 = 1.8
  G1 = 1.8
  G3 = 0
  PULSE_CMFB = 0
  VAC_CM = 0
  VCM_PULSE = 0
  VDC_CM = 900m
  VDD_PULSE = 0
  VIN_AC = 1
  VIN_PULSE = 0
  Vsupply = 1.8
  AMP_IN = 1m
  FLO = 1k
  IQ_CTRL = 0,1.8
  FREQ = FLO
