ADE simulation setup
Run mode: Single Run, Sweeps and Corners
Tests:
  IMP_AN_TIA:tia_lna_tb:1 (off): IMP_AN_TIA/tia_lna_tb/config, simulator ams
    Outputs: VOUT
  IMP_AN_TIA:tia_lna_tb:2: IMP_AN_TIA/tia_lna_tb/config, simulator spectre
Global variables:
  AMP_IN = 1m
  CEXT = 1.5n
  CMFB_AC = 0
  CMFB_PULSE = 0
  CMFB_VAC = 0
  CPAD = 600f
  DC_IN = 0
  FLO = 4k
  FREQ = FLO
  G0 = 1.8
  G1 = 1.8
  G3 = 0
  IQ_CTRL = 0,1.8
  PULSE_CMFB = 0
  VAC_CM = 0
  VCM_PULSE = 0
  VDC_CM = 900m
  VDD_PULSE = 0
  VIN_AC = 1
  VIN_PULSE = 0
  Vsupply = 1.8
  AM_FREQ = 0
  CM_AMP = 0
  CM_FREQ = 5k
  AMP_PHA = 0
Corners (all switched off):
  model folders: /pkg/AMS/spectre/h18
  every corner: /pkg/AMS/spectre/h18/mcparams.scs, /pkg/AMS/spectre/h18/design.scs[noitm], /pkg/AMS/spectre/h18/bip.scs[biptm], /pkg/AMS/spectre/h18/esddi.scs[esdditm]
  C1_0: res.scs[reswp], cap.scs[capwp], cmos53.scs[cmosfff]
  C1_1: res.scs[resws], cap.scs[capwp], cmos53.scs[cmosfff]
  C1_2: res.scs[reswp], cap.scs[capws], cmos53.scs[cmosfff]
  C1_3: res.scs[resws], cap.scs[capws], cmos53.scs[cmosfff]
  C1_4: res.scs[reswp], cap.scs[capwp], cmos53.scs[cmosssf]
  C1_5: res.scs[resws], cap.scs[capwp], cmos53.scs[cmosssf]
  C1_6: res.scs[reswp], cap.scs[capws], cmos53.scs[cmosssf]
  C1_7: res.scs[resws], cap.scs[capws], cmos53.scs[cmosssf]
  C1_8: res.scs[reswp], cap.scs[capwp], cmos53.scs[cmoswo]
  C1_9: res.scs[resws], cap.scs[capwp], cmos53.scs[cmoswo]
  C1_10: res.scs[reswp], cap.scs[capws], cmos53.scs[cmoswo]
  C1_11: res.scs[resws], cap.scs[capws], cmos53.scs[cmoswo]
  C1_12: res.scs[reswp], cap.scs[capwp], cmos53.scs[cmoswz]
  C1_13: res.scs[resws], cap.scs[capwp], cmos53.scs[cmoswz]
  C1_14: res.scs[reswp], cap.scs[capws], cmos53.scs[cmoswz]
  C1_15: res.scs[resws], cap.scs[capws], cmos53.scs[cmoswz]
