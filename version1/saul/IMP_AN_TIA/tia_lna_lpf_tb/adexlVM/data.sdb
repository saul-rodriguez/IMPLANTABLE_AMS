ADE simulation setup
Run mode: Single Run, Sweeps and Corners
Tests:
  IMP_AN_TIA:tia_lna_lpf_tb:1: IMP_AN_TIA/tia_lna_lpf_tb/config, simulator ams
    Outputs: (VT("/VOUTP") - VT("/VOUTN")); (VT("/VOP_LPF") - VT("/VON_LPF"))
Global variables:
  AMP_IN = 45m
  AMP_PHA = 0
  C_LPF = 0.5n
  CEXT = 1n
  CLOCKWIDTH = 15625
  CM_AMP = 0
  CM_FREQ = 5k
  CMFB_AC = 0
  CMFB_PULSE_TIA = 0
  CMFB_VAC = 0
  CPAD = 650f
  DC_IN = 0
  FREQ = 1k
  G0 = 1.8
  G1 = 0
  G3 = 1.8
  IQ_CTRL = 0,1.8
  PULSE_CMFB_LNA = 0
  STEPNUM = 0
  VAC_CM = 0
  VCM_PULSE = 0
  VDC_CM = 900m
  VDD_PULSE = 0
  VIN_AC = 0
  VIN_PULSE = 0
  Vsupply = 1.8
Corners:
  model folders: /pkg/AMS/spectre/h18/soac
  every corner: /pkg/AMS/spectre/h18/soac/mcparams.scs, /pkg/AMS/spectre/h18/soac/design.scs[noitm], /pkg/AMS/spectre/h18/soac/bip.scs[biptm], /pkg/AMS/spectre/h18/soac/esddi.scs[esdditm]
  C0_0: res.scs[reswp], cap.scs[capwp], cmos53.scs[cmosfff]
  C0_1: res.scs[resws], cap.scs[capwp], cmos53.scs[cmosfff]
  C0_2: res.scs[reswp], cap.scs[capws], cmos53.scs[cmosfff]
  C0_3: res.scs[resws], cap.scs[capws], cmos53.scs[cmosfff]
  C0_4: res.scs[reswp], cap.scs[capwp], cmos53.scs[cmosssf]
  C0_5: res.scs[resws], cap.scs[capwp], cmos53.scs[cmosssf]
  C0_6: res.scs[reswp], cap.scs[capws], cmos53.scs[cmosssf]
  C0_7: res.scs[resws], cap.scs[capws], cmos53.scs[cmosssf]
  C0_8: res.scs[reswp], cap.scs[capwp], cmos53.scs[cmoswo]
  C0_9: res.scs[resws], cap.scs[capwp], cmos53.scs[cmoswo]
  C0_10: res.scs[reswp], cap.scs[capws], cmos53.scs[cmoswo]
  C0_11: res.scs[resws], cap.scs[capws], cmos53.scs[cmoswo]
  C0_12: res.scs[reswp], cap.scs[capwp], cmos53.scs[cmoswz]
  C0_13: res.scs[resws], cap.scs[capwp], cmos53.scs[cmoswz]
  C0_14: res.scs[reswp], cap.scs[capws], cmos53.scs[cmoswz]
  C0_15: res.scs[resws], cap.scs[capws], cmos53.scs[cmoswz]
