ADE simulation setup
Run mode: Single Run, Sweeps and Corners
Tests:
  IMP_AN_TIA:tia_lna_lpf_tb:1 (off): IMP_AN_TIA/tia_lna_lpf_tb/config, simulator ams
    Outputs: VOUT_TIA; VOUT_LPF
  IMP_AN_TIA:tia_lna_lpf_tb:1:1: IMP_AN_TIA/tia_lna_lpf_tb/config, simulator ams
    Outputs: VOUT_TIA; VOUT_LPF
Global variables:
  AMP_IN = 0
  AMP_PHA = 0
  CEXT = 10p
  CM_AMP = 0
  CM_FREQ = 5k
  CMFB_AC = 0
  CMFB_PULSE = 0
  CMFB_VAC = 0
  CPAD = 650f
  DC_IN = 0
  FLO = 1k
  FREQ = FLO
  G0 = 0,1.8
  G1 = 0,1.8
  G3 = 0,1.8
  IQ_CTRL = 0
  PULSE_CMFB = 0
  VAC_CM = 0
  VCM_PULSE = 10m
  VDC_CM = 900m
  VDD_PULSE = 0
  VIN_AC = 1
  VIN_PULSE = 0
  Vsupply = 1.8
  C_LPF = 0.5n
  CMFB_PULSE_TIA = 0
  PULSE_CMFB_LNA = 0
  CLOCKWIDTH = 15625
  STEPNUM = 0
Corners (all switched off):
  model folders: /pkg/AMS411/spectre/h18/soac
  every corner: /pkg/AMS411/spectre/h18/soac/mcparams.scs, /pkg/AMS411/spectre/h18/soac/design.scs[noitm], /pkg/AMS411/spectre/h18/soac/bip.scs[biptm], /pkg/AMS411/spectre/h18/soac/esddi.scs[esdditm]
  C0_0: res.scs[reswp], cap.scs[capwp], cmos53.scs[cmosfff]
  C0_1: res.scs[resws], cap.scs[capwp], cmos53.scs[cmosfff]
  C0_2: res.scs[reswp], cap.scs[capws], cmos53.scs[cmosfff]
  C0_3: res.scs[resws], cap.scs[capws], cmos53.scs[cmosfff]
  C0_4: res.scs[reswp], cap.scs[capwp], cmos53.scs[cmosssf]
  C0_5: res.scs[resws], cap.scs[capwp], cmos53.scs[cmosssf]
  C0_6: res.scs[reswp], cap.scs[capws], cmos53.scs[cmosssf]
  C0_7: res.scs[resws], cap.scs[capws], cmos53.scs[cmosssf]
  C0_8: res.scs[reswp], cap.scs[capwp], cmos53.scs[cmoswo]
  C0_9: res.scs[resws], cap.scs[capwp], cmos53.scs[cmoswo]
  C0_10: res.scs[reswp], cap.scs[capws], cmos53.scs[cmoswo]
  C0_11: res.scs[resws], cap.scs[capws], cmos53.scs[cmoswo]
  C0_12: res.scs[reswp], cap.scs[capwp], cmos53.scs[cmoswz]
  C0_13: res.scs[resws], cap.scs[capwp], cmos53.scs[cmoswz]
  C0_14: res.scs[reswp], cap.scs[capws], cmos53.scs[cmoswz]
  C0_15: res.scs[resws], cap.scs[capws], cmos53.scs[cmoswz]
