ADE simulation setup
Run mode: Single Run, Sweeps and Corners
Tests:
  IMP_AN_TIA:tia_tb:1: IMP_AN_TIA/tia_tb/config, simulator spectre
    Outputs: (VF("/VOUTP") - VF("/VOUTN"))
Global variables:
  CEXT = 4.7n
  CM_AC = 0
  CM_PULSE = 0
  CMFB_AC = 0
  CMFB_PULSE_TIA = 0
  GAIN = 0
  IN_AC = 1
  IN_AMP = 0
  IN_DC = 0
  IN_FREQ = 1k
  IN_PULSE = 100n
  VDD_PULSE = 0
  Vsupply = 1.8
Corners:
  model folders: /pkg/AMS411/spectre/h18
  every corner: /pkg/AMS411/spectre/h18/mcparams.scs, /pkg/AMS411/spectre/h18/design.scs[noitm], /pkg/AMS411/spectre/h18/bip.scs[biptm], /pkg/AMS411/spectre/h18/esddi.scs[esdditm]
  C0_0: Vsupply=1.62; res.scs[reswp], cap.scs[capwp], cmos53.scs[cmosfff]
  C0_1: Vsupply=1.8; res.scs[reswp], cap.scs[capwp], cmos53.scs[cmosfff]
  C0_2: Vsupply=1.98; res.scs[reswp], cap.scs[capwp], cmos53.scs[cmosfff]
  C0_3: Vsupply=1.62; res.scs[resws], cap.scs[capwp], cmos53.scs[cmosfff]
  C0_4: Vsupply=1.8; res.scs[resws], cap.scs[capwp], cmos53.scs[cmosfff]
  C0_5: Vsupply=1.98; res.scs[resws], cap.scs[capwp], cmos53.scs[cmosfff]
  C0_6: Vsupply=1.62; res.scs[reswp], cap.scs[capws], cmos53.scs[cmosfff]
  C0_7: Vsupply=1.8; res.scs[reswp], cap.scs[capws], cmos53.scs[cmosfff]
  C0_8: Vsupply=1.98; res.scs[reswp], cap.scs[capws], cmos53.scs[cmosfff]
  C0_9: Vsupply=1.62; res.scs[resws], cap.scs[capws], cmos53.scs[cmosfff]
  C0_10: Vsupply=1.8; res.scs[resws], cap.scs[capws], cmos53.scs[cmosfff]
  C0_11: Vsupply=1.98; res.scs[resws], cap.scs[capws], cmos53.scs[cmosfff]
  C0_12: Vsupply=1.62; res.scs[reswp], cap.scs[capwp], cmos53.scs[cmosssf]
  C0_13: Vsupply=1.8; res.scs[reswp], cap.scs[capwp], cmos53.scs[cmosssf]
  C0_14: Vsupply=1.98; res.scs[reswp], cap.scs[capwp], cmos53.scs[cmosssf]
  C0_15: Vsupply=1.62; res.scs[resws], cap.scs[capwp], cmos53.scs[cmosssf]
  C0_16: Vsupply=1.8; res.scs[resws], cap.scs[capwp], cmos53.scs[cmosssf]
  C0_17: Vsupply=1.98; res.scs[resws], cap.scs[capwp], cmos53.scs[cmosssf]
  C0_18: Vsupply=1.62; res.scs[reswp], cap.scs[capws], cmos53.scs[cmosssf]
  C0_19: Vsupply=1.8; res.scs[reswp], cap.scs[capws], cmos53.scs[cmosssf]
  C0_20: Vsupply=1.98; res.scs[reswp], cap.scs[capws], cmos53.scs[cmosssf]
  C0_21: Vsupply=1.62; res.scs[resws], cap.scs[capws], cmos53.scs[cmosssf]
  C0_22: Vsupply=1.8; res.scs[resws], cap.scs[capws], cmos53.scs[cmosssf]
  C0_23: Vsupply=1.98; res.scs[resws], cap.scs[capws], cmos53.scs[cmosssf]
  C0_24: Vsupply=1.62; res.scs[reswp], cap.scs[capwp], cmos53.scs[cmoswo]
  C0_25: Vsupply=1.8; res.scs[reswp], cap.scs[capwp], cmos53.scs[cmoswo]
  C0_26: Vsupply=1.98; res.scs[reswp], cap.scs[capwp], cmos53.scs[cmoswo]
  C0_27: Vsupply=1.62; res.scs[resws], cap.scs[capwp], cmos53.scs[cmoswo]
  C0_28: Vsupply=1.8; res.scs[resws], cap.scs[capwp], cmos53.scs[cmoswo]
  C0_29: Vsupply=1.98; res.scs[resws], cap.scs[capwp], cmos53.scs[cmoswo]
  C0_30: Vsupply=1.62; res.scs[reswp], cap.scs[capws], cmos53.scs[cmoswo]
  C0_31: Vsupply=1.8; res.scs[reswp], cap.scs[capws], cmos53.scs[cmoswo]
  C0_32: Vsupply=1.98; res.scs[reswp], cap.scs[capws], cmos53.scs[cmoswo]
  C0_33: Vsupply=1.62; res.scs[resws], cap.scs[capws], cmos53.scs[cmoswo]
  C0_34: Vsupply=1.8; res.scs[resws], cap.scs[capws], cmos53.scs[cmoswo]
  C0_35: Vsupply=1.98; res.scs[resws], cap.scs[capws], cmos53.scs[cmoswo]
  C0_36: Vsupply=1.62; res.scs[reswp], cap.scs[capwp], cmos53.scs[cmoswz]
  C0_37: Vsupply=1.8; res.scs[reswp], cap.scs[capwp], cmos53.scs[cmoswz]
  C0_38: Vsupply=1.98; res.scs[reswp], cap.scs[capwp], cmos53.scs[cmoswz]
  C0_39: Vsupply=1.62; res.scs[resws], cap.scs[capwp], cmos53.scs[cmoswz]
  C0_40: Vsupply=1.8; res.scs[resws], cap.scs[capwp], cmos53.scs[cmoswz]
  C0_41: Vsupply=1.98; res.scs[resws], cap.scs[capwp], cmos53.scs[cmoswz]
  C0_42: Vsupply=1.62; res.scs[reswp], cap.scs[capws], cmos53.scs[cmoswz]
  C0_43: Vsupply=1.8; res.scs[reswp], cap.scs[capws], cmos53.scs[cmoswz]
  C0_44: Vsupply=1.98; res.scs[reswp], cap.scs[capws], cmos53.scs[cmoswz]
  C0_45: Vsupply=1.62; res.scs[resws], cap.scs[capws], cmos53.scs[cmoswz]
  C0_46: Vsupply=1.8; res.scs[resws], cap.scs[capws], cmos53.scs[cmoswz]
  C0_47: Vsupply=1.98; res.scs[resws], cap.scs[capws], cmos53.scs[cmoswz]
