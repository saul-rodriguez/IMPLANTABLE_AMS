ADE simulation setup
Run mode: Monte Carlo Sampling
Tests:
  IMP_AN_TIA:tia_tb:1: IMP_AN_TIA/tia_tb/config, simulator spectre
  IMP_AN_TIA:tia_tb:1:1 (off): IMP_AN_TIA/tia_tb/config, simulator spectre
Global variables:
  GAIN = 0
  Vsupply = 1.8
  VDD_PULSE = 0
  CEXT = 4.7n
  cc2 = 1p
  CMFB_AC = 0
  CMFB_PULSE = 0
  IN_AC = 1
  IN_FREQ = 1k
  IN_AMP = 0
  IN_DC = 0
  IN_PULSE = 0
  rc = 6k
  RF = 450k
  CM_PULSE = 0
Corners (all switched off):
  model folders: /pkg/AMS411/spectre/h18/soac
  every corner: /pkg/AMS411/spectre/h18/soac/mcparams.scs, /pkg/AMS411/spectre/h18/soac/design.scs[noitm], /pkg/AMS411/spectre/h18/soac/bip.scs[biptm], /pkg/AMS411/spectre/h18/soac/esddi.scs[esdditm]
  C0_0: res.scs[reswp], cap.scs[capwp], cmos53.scs[cmosfff]
  C0_1: res.scs[resws], cap.scs[capwp], cmos53.scs[cmosfff]
  C0_2: res.scs[reswp], cap.scs[capws], cmos53.scs[cmosfff]
  C0_3: res.scs[resws], cap.scs[capws], cmos53.scs[cmosfff]
  C0_4: res.scs[reswp], cap.scs[capwp], cmos53.scs[cmosssf]
  C0_5: res.scs[resws], cap.scs[capwp], cmos53.scs[cmosssf]
  C0_6: res.scs[reswp], cap.scs[capws], cmos53.scs[cmosssf]
  C0_7: res.scs[resws], cap.scs[capws], cmos53.scs[cmosssf]
  C0_8: res.scs[reswp], cap.scs[capwp], cmos53.scs[cmoswo]
  C0_9: res.scs[resws], cap.scs[capwp], cmos53.scs[cmoswo]
  C0_10: res.scs[reswp], cap.scs[capws], cmos53.scs[cmoswo]
  C0_11: res.scs[resws], cap.scs[capws], cmos53.scs[cmoswo]
  C0_12: res.scs[reswp], cap.scs[capwp], cmos53.scs[cmoswz]
  C0_13: res.scs[resws], cap.scs[capwp], cmos53.scs[cmoswz]
  C0_14: res.scs[reswp], cap.scs[capws], cmos53.scs[cmoswz]
  C0_15: res.scs[resws], cap.scs[capws], cmos53.scs[cmoswz]
Monte Carlo Sampling options: mcmethod=all, mcnumpoints=200
