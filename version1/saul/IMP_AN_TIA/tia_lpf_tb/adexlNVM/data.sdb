ADE simulation setup
Run mode: Single Run, Sweeps and Corners
Tests:
  IMP_AN_TIA:tia_lpf_tb:1 (off): IMP_AN_TIA/tia_lpf_tb/config, simulator spectre
  IMP_AN_TIA:tia_lpf_tb:2: IMP_AN_TIA/tia_lpf_tb/config, simulator ams
Global variables:
  CEXT = 4.7n
  CM_AC = 0
  CM_PULSE = 0
  CMFB_AC = 0
  CMFB_PULSE = 0
  GAIN = 1.8
  IN_AC = 1
  IN_AMP = 0
  IN_DC = 0
  IN_FREQ = 1k
  IN_PULSE = 0
  VDD_PULSE = 0
  Vsupply = 1.8
