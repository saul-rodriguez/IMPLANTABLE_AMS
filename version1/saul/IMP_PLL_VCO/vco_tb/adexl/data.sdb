ADE simulation setup
Run mode: Single Run, Sweeps and Corners
Tests:
  IMP_PLL_VCO:vco_tb:1: IMP_PLL_VCO/vco_tb/config, simulator spectre
Global variables:
  Cload = 15f
  fmax = 37.5M
  VIN_CTRL = 1.2
