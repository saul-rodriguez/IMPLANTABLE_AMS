ADE simulation setup
Run mode: Single Run, Sweeps and Corners
Tests:
  IMP_POW_REF_BIAS:ref_bias_tb:1: IMP_POW_REF_BIAS/ref_bias_tb/schematic, simulator spectre
Global variables:
  V_REF = 1.25
  V_REF_AC = 1
  VD_AC = 0
  VD_PULSE = 0
  VREF_PULSE = 0
  Vsupply = 1.8
Corners (all switched off):
  model folders: /afs/ict.kth.se/proj/ektlab/PDK/AMS/spectre/h18/soac
  every corner: /afs/ict.kth.se/proj/ektlab/PDK/AMS/spectre/h18/soac/mcparams.scs, /afs/ict.kth.se/proj/ektlab/PDK/AMS/spectre/h18/soac/design.scs[noitm], /afs/ict.kth.se/proj/ektlab/PDK/AMS/spectre/h18/soac/bip.scs[biptm], /afs/ict.kth.se/proj/ektlab/PDK/AMS/spectre/h18/soac/esddi.scs[esdditm]
  C0_0: Vsupply=1.62; res.scs[reswp], cap.scs[capwp], cmos53.scs[cmosfff]
  C0_1: Vsupply=1.98; res.scs[reswp], cap.scs[capwp], cmos53.scs[cmosfff]
  C0_2: Vsupply=1.62; res.scs[resws], cap.scs[capwp], cmos53.scs[cmosfff]
  C0_3: Vsupply=1.98; res.scs[resws], cap.scs[capwp], cmos53.scs[cmosfff]
  C0_4: Vsupply=1.62; res.scs[reswp], cap.scs[capws], cmos53.scs[cmosfff]
  C0_5: Vsupply=1.98; res.scs[reswp], cap.scs[capws], cmos53.scs[cmosfff]
  C0_6: Vsupply=1.62; res.scs[resws], cap.scs[capws], cmos53.scs[cmosfff]
  C0_7: Vsupply=1.98; res.scs[resws], cap.scs[capws], cmos53.scs[cmosfff]
  C0_8: Vsupply=1.62; res.scs[reswp], cap.scs[capwp], cmos53.scs[cmosssf]
  C0_9: Vsupply=1.98; res.scs[reswp], cap.scs[capwp], cmos53.scs[cmosssf]
  C0_10: Vsupply=1.62; res.scs[resws], cap.scs[capwp], cmos53.scs[cmosssf]
  C0_11: Vsupply=1.98; res.scs[resws], cap.scs[capwp], cmos53.scs[cmosssf]
  C0_12: Vsupply=1.62; res.scs[reswp], cap.scs[capws], cmos53.scs[cmosssf]
  C0_13: Vsupply=1.98; res.scs[reswp], cap.scs[capws], cmos53.scs[cmosssf]
  C0_14: Vsupply=1.62; res.scs[resws], cap.scs[capws], cmos53.scs[cmosssf]
  C0_15: Vsupply=1.98; res.scs[resws], cap.scs[capws], cmos53.scs[cmosssf]
  C0_16: Vsupply=1.62; res.scs[reswp], cap.scs[capwp], cmos53.scs[cmoswo]
  C0_17: Vsupply=1.98; res.scs[reswp], cap.scs[capwp], cmos53.scs[cmoswo]
  C0_18: Vsupply=1.62; res.scs[resws], cap.scs[capwp], cmos53.scs[cmoswo]
  C0_19: Vsupply=1.98; res.scs[resws], cap.scs[capwp], cmos53.scs[cmoswo]
  C0_20: Vsupply=1.62; res.scs[reswp], cap.scs[capws], cmos53.scs[cmoswo]
  C0_21: Vsupply=1.98; res.scs[reswp], cap.scs[capws], cmos53.scs[cmoswo]
  C0_22: Vsupply=1.62; res.scs[resws], cap.scs[capws], cmos53.scs[cmoswo]
  C0_23: Vsupply=1.98; res.scs[resws], cap.scs[capws], cmos53.scs[cmoswo]
  C0_24: Vsupply=1.62; res.scs[reswp], cap.scs[capwp], cmos53.scs[cmoswz]
  C0_25: Vsupply=1.98; res.scs[reswp], cap.scs[capwp], cmos53.scs[cmoswz]
  C0_26: Vsupply=1.62; res.scs[resws], cap.scs[capwp], cmos53.scs[cmoswz]
  C0_27: Vsupply=1.98; res.scs[resws], cap.scs[capwp], cmos53.scs[cmoswz]
  C0_28: Vsupply=1.62; res.scs[reswp], cap.scs[capws], cmos53.scs[cmoswz]
  C0_29: Vsupply=1.98; res.scs[reswp], cap.scs[capws], cmos53.scs[cmoswz]
  C0_30: Vsupply=1.62; res.scs[resws], cap.scs[capws], cmos53.scs[cmoswz]
  C0_31: Vsupply=1.98; res.scs[resws], cap.scs[capws], cmos53.scs[cmoswz]
