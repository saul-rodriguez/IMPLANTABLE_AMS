ADE simulation setup
Run mode: Single Run, Sweeps and Corners
Tests:
  IMP_POW_REF_BIAS:ref_bias_tb:1: IMP_POW_REF_BIAS/ref_bias_tb/config, simulator spectre
Global variables:
  V_REF = 1.25
  V_REF_AC = 0
  VD_AC = 0
  VD_PULSE = 0
  VREF_PULSE = 0
  Vsupply = 1.8
