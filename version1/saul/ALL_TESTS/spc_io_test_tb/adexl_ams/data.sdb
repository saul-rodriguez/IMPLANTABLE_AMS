ADE simulation setup
Run mode: Single Run, Sweeps and Corners
Tests:
  ALL_TESTS:spc_io_test_tb:1: ALL_TESTS/spc_io_test_tb/config, simulator ams
  ALL_TESTS:spc_io_test_tb:2 (off): ALL_TESTS/spc_io_test_tb/config, simulator spectre
Global variables:
  VDC = 1.8
