ADE simulation setup
Run mode: Single Run, Sweeps and Corners
Tests:
  ALL_TESTS:spc_io_test_tb:1: ALL_TESTS/spc_io_test_tb/config_old, simulator spectre
  ALL_TESTS:spc_io_test_tb:2 (off): ALL_TESTS/spc_io_test_tb/config_old, simulator ams
Global variables:
  VDC = 1.8
