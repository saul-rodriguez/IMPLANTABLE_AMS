ADE simulation setup
Run mode: Monte Carlo Sampling
Tests:
  ALL_TESTS:ldo_test_b:1: ALL_TESTS/ldo_test_b/schematic, simulator spectre
    Outputs: IDC("/I0/TP4/D")
Global variables:
  CL = 10u
  RL = 10k
  VD_AC = 0
  VIN_PULSE = 0
  VREF = 1.2
  VREF_AC = 1
  Vsupply = 3
Corners:
  model folders: /afs/ict.kth.se/proj/ektlab/PDK/AMS/spectre/h18/soac
  corner (off): temperature=27; Vsupply=3; design.scs[noitm], cap.scs[capwp capws], esddi.scs[esdditm], bip.scs[biptm], res.scs[reswp resws], cmos53.scs[cmoswo cmoswz cmosfff cmosssf]
Monte Carlo Sampling options: mcmethod=all, mcnumpoints=10
