ADE simulation setup
Run mode: Monte Carlo Sampling
Tests:
  ALL_TESTS:current_mirror:1: ALL_TESTS/current_mirror/schematic, simulator spectre
    Outputs: IDC("/TN3/D"); VDC("/VGS")
Global variables:
  IDC = 0.01u
  L = 0.18u
  W = 50u
Monte Carlo Sampling options: mcmethod=all, mcnumpoints=200
