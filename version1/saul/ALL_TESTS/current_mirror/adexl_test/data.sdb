ADE simulation setup
Run mode: Single Run, Sweeps and Corners
Tests:
  ALL_TESTS:current_mirror:1: ALL_TESTS/current_mirror/schematic, simulator spectre
Global variables:
  IDC = 1u
  L = 1u
  W = 10u
Corners:
  model folders: /afs/ict.kth.se/proj/ektlab/PDK/AMS/spectre/h18
  corner: temperature=27; Vsupply=1.8; design.scs[noitm], cap.scs[captm], esddi.scs[esdditm], bip.scs[biptm], res.scs[restm], cmos53.scs[cmoswo cmoswz cmosfff cmosssf]
