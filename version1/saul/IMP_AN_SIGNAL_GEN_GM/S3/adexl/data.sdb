ADE simulation setup
Run mode: Single Run, Sweeps and Corners
Tests:
  IMP_AN_SIGNAL_GEN_GM:S3:1: IMP_AN_SIGNAL_GEN_GM/S3/schematic, simulator spectre
    Outputs: phase_res
Global variables:
  VAC_CM = 1
  DC_IN = 0
  VDC_CM = 0.9
  VIN_AC = 0
  VIN_PULSE = 0
  CMFB_VAC = 1
