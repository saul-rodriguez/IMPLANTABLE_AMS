ADE simulation setup
Run mode: Single Run, Sweeps and Corners
Tests:
  IMP_AN_SIGNAL_GEN_GM:S3_TB:2: IMP_AN_SIGNAL_GEN_GM/S3_TB/schematic, simulator spectre
    Outputs: MAG1M; PHA1M
  IMP_AN_SIGNAL_GEN_GM:S3_TB:1 (off): IMP_AN_SIGNAL_GEN_GM/S3_TB/config, simulator ams
    Outputs: GAIN; GAINDB
Global variables:
  CMFB_VAC = 0
  DC_IN = 0
  G0 = 0
  G1 = 0
  G2 = 1.8
  G3 = 1.8
  I_REF = 11.11u
  PULSE_CMFB = 0
  RL = 1000
  VAC_CM = 0
  VCM_PULSE = 0
  VDC_CM = 900m
  VIN_AC = 1
  VIN_PULSE = 10m
  CPAD = 4p
  VDD_PULSE = 0
Corners:
  model folders: /pkg/AMS411/spectre/h18/soac
  every corner: /pkg/AMS411/spectre/h18/soac/mcparams.scs, /pkg/AMS411/spectre/h18/soac/design.scs[noimax], /pkg/AMS411/spectre/h18/soac/bip.scs[biptm], /pkg/AMS411/spectre/h18/soac/esddi.scs[esdditm]
  C0_0 (off): res.scs[reswp], cap.scs[capwp], cmos53.scs[cmosfff]
  C0_1 (off): res.scs[resws], cap.scs[capwp], cmos53.scs[cmosfff]
  C0_2 (off): res.scs[reswp], cap.scs[capws], cmos53.scs[cmosfff]
  C0_3 (off): res.scs[resws], cap.scs[capws], cmos53.scs[cmosfff]
  C0_4 (off): res.scs[reswp], cap.scs[capwp], cmos53.scs[cmosssf]
  C0_5 (off): res.scs[resws], cap.scs[capwp], cmos53.scs[cmosssf]
  C0_6 (off): res.scs[reswp], cap.scs[capws], cmos53.scs[cmosssf]
  C0_7 (off): res.scs[resws], cap.scs[capws], cmos53.scs[cmosssf]
  C0_8 (off): res.scs[reswp], cap.scs[capwp], cmos53.scs[cmoswo]
  C0_9 (off): res.scs[resws], cap.scs[capwp], cmos53.scs[cmoswo]
  C0_10 (off): res.scs[reswp], cap.scs[capws], cmos53.scs[cmoswo]
  C0_11 (off): res.scs[resws], cap.scs[capws], cmos53.scs[cmoswo]
  C0_12 (off): res.scs[reswp], cap.scs[capwp], cmos53.scs[cmoswz]
  C0_13 (off): res.scs[resws], cap.scs[capwp], cmos53.scs[cmoswz]
  C0_14 (off): res.scs[reswp], cap.scs[capws], cmos53.scs[cmoswz]
  C0_15 (off): res.scs[resws], cap.scs[capws], cmos53.scs[cmoswz]
