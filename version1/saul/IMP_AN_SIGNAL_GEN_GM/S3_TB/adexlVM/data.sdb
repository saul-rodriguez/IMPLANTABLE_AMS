ADE simulation setup
Run mode: Single Run, Sweeps and Corners
Tests:
  IMP_AN_SIGNAL_GEN_GM:S3_TB:1: IMP_AN_SIGNAL_GEN_GM/S3_TB/schematic, simulator spectre
    Outputs: (VT("/OUTP") - VT("/OUTN")); CM_GAIN; GAIN_ac_db
  IMP_AN_SIGNAL_GEN_GM:S3_TB:2 (off): IMP_AN_SIGNAL_GEN_GM/S3_TB/config, simulator ams
Global variables:
  CMFB_VAC = 1
  DC_IN = 0
  G0 = 0
  G1 = 0
  G2 = 1.8
  G3 = 1.8
  I_REF = 100u
  PULSE_CMFB = 0
  RL = 1.2k
  VAC_CM = 0
  VCM_PULSE = 0
  VDC_CM = 1000m
  VIN_AC = 0
  VIN_PULSE = 0
  CPAD = 0
  VDD_PULSE = 10m
Corners (all switched off):
  model folders: /pkg/AMS/spectre/h18/soac
  every corner: /pkg/AMS/spectre/h18/soac/mcparams.scs, /pkg/AMS/spectre/h18/soac/design.scs[noitm], /pkg/AMS/spectre/h18/soac/bip.scs[biptm], /pkg/AMS/spectre/h18/soac/esddi.scs[esdditm]
  C0_0: res.scs[reswp], cap.scs[capwp], cmos53.scs[cmosfff]
  C0_1: res.scs[resws], cap.scs[capwp], cmos53.scs[cmosfff]
  C0_2: res.scs[reswp], cap.scs[capws], cmos53.scs[cmosfff]
  C0_3: res.scs[resws], cap.scs[capws], cmos53.scs[cmosfff]
  C0_4: res.scs[reswp], cap.scs[capwp], cmos53.scs[cmosssf]
  C0_5: res.scs[resws], cap.scs[capwp], cmos53.scs[cmosssf]
  C0_6: res.scs[reswp], cap.scs[capws], cmos53.scs[cmosssf]
  C0_7: res.scs[resws], cap.scs[capws], cmos53.scs[cmosssf]
  C0_8: res.scs[reswp], cap.scs[capwp], cmos53.scs[cmoswo]
  C0_9: res.scs[resws], cap.scs[capwp], cmos53.scs[cmoswo]
  C0_10: res.scs[reswp], cap.scs[capws], cmos53.scs[cmoswo]
  C0_11: res.scs[resws], cap.scs[capws], cmos53.scs[cmoswo]
  C0_12: res.scs[reswp], cap.scs[capwp], cmos53.scs[cmoswz]
  C0_13: res.scs[resws], cap.scs[capwp], cmos53.scs[cmoswz]
  C0_14: res.scs[reswp], cap.scs[capws], cmos53.scs[cmoswz]
  C0_15: res.scs[resws], cap.scs[capws], cmos53.scs[cmoswz]
