ADE simulation setup
Run mode: Monte Carlo Sampling
Tests:
  IMP_AN_SIGNAL_GEN_GM:S3_TB:1: IMP_AN_SIGNAL_GEN_GM/S3_TB/schematic, simulator spectre
  IMP_AN_SIGNAL_GEN_GM:S3_TB:2 (off): IMP_AN_SIGNAL_GEN_GM/S3_TB/config, simulator ams
Global variables:
  CMFB_VAC = 0
  DC_IN = 0
  G0 = 1.8
  G1 = 1.8
  G2 = 1.8
  G3 = 1.8
  I_REF = 100u
  PULSE_CMFB = 0
  RL = 100
  VAC_CM = 0
  VCM_PULSE = 0
  VDC_CM = 1000m
  VIN_AC = 1
  VIN_PULSE = 0
  CPAD = 3p
  VDD_PULSE = 0
Monte Carlo Sampling options: mcmethod=all, mcnumpoints=200
