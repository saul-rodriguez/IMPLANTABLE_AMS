ADE simulation setup
Run mode: Single Run, Sweeps and Corners
Tests:
  IMP_AN_SIGNAL_GEN_GM:Signal_Generator_bias_tb:1: IMP_AN_SIGNAL_GEN_GM/Signal_Generator_bias_tb/config, simulator spectre
Global variables:
  G2 = 0
  G3 = 0
