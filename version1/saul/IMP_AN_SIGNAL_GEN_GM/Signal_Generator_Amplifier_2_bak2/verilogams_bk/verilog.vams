//Verilog-AMS HDL for "IMP_AN_SIGNAL_GEN_GM", "Signal_Generator_Amplifier" "verilogams"

`timescale 1ns/1ps
`include "constants.vams"
`include "disciplines.vams"

module Signal_Generator_Amplifier_2_bak2( bias_CMFB, bias_DAC, bias_in, G0, G1, IoutN,
IoutP, VIN_N, VIN_P, vdda, vddd, vssa, vssd, vsub );

  input vsub;
  input IoutP;
  input G0;
  input VIN_P;
  input VIN_N;
  input G1;
  input vssd;
  input vdda;
  input IoutN;
  output bias_in;
  input vssa;
  input vddd;
  output bias_DAC;
  output bias_CMFB;

  logic G0,G1;
  electrical VIN_P, VIN_N, IoutN, IoutP, vssa;
  electrical bias_DAC,bias_CMFB;

//  parameter real GM = 1.0m; //Transconductance
  parameter real vcm = 0.9; //Common mode voltage
  parameter real Av = 20000; //DC voltage Gain
  parameter real I_bias_DAC = 2u;
  parameter real I_bias_CMFB = 0.5u;
  parameter real GM0 = 11.11111u;
  real GM; //Transconductance
  real Gout, Gout_se, vodif;

  analog begin
  	@(initial_step) begin
		if (G1 == 0 && G0 == 0) 	 //G1G0 = 00
			GM = GM0;
		else if (G1 == 0 && G0 == 1) //G1G0 = 01
			GM = 3*GM0;
		else 						 //G1G0 = 11
			GM = 9*GM0;

		Gout=GM/Av;  //Gout differential
		Gout_se = 2*Gout; //Gout single ended
    end

	@(posedge G0)begin
		if (G1 == 0) begin
			GM = 3*GM0;
			Gout=GM/Av;  //Gout differential
			Gout_se = 2*Gout; //Gout single ended
		end else begin
			GM = 9*GM0;
			Gout=GM/Av;  //Gout differential
			Gout_se = 2*Gout; //Gout single ended
		end
	end

	@(negedge G0) begin
		if (G1 == 0) begin
			GM = GM0;
			Gout=GM/Av;  //Gout differential
			Gout_se = 2*Gout; //Gout single ended
		end else begin
			GM = 8*GM0;  // NOTE: This gain should not be set!
			Gout=GM/Av;  //Gout differential
			Gout_se = 2*Gout; //Gout single ended

		end

	end

	@(posedge G1)begin
		if (G0 == 1) begin
			GM = 9*GM0;
			Gout=GM/Av;  //Gout differential
			Gout_se = 2*Gout; //Gout single ended
		end else begin
			GM = 8*GM0;  // NOTE: This gain should not be set!
			Gout=GM/Av;  //Gout differential
			Gout_se = 2*Gout; //Gout single ended
		end
	end

	@(negedge G1) begin
		if (G0 == 1) begin
			GM = 3*GM0;
			Gout=GM/Av;  //Gout differential
			Gout_se = 2*Gout; //Gout single ended
		end else begin
			GM = GM0;
			Gout=GM/Av;  //Gout differential
			Gout_se = 2*Gout; //Gout single ended
		end
	end

	vodif = Av*V(VIN_P,VIN_N); // Differential gain (DC)
	//Amplifier Ouput current

	I(IoutP,vssa) <+ (V(IoutP,vssa)-(vcm+vodif/2))*Gout_se;
	I(IoutN,vssa) <+ (V(IoutN,vssa)-(vcm-vodif/2))*Gout_se;

	//Biasing for other stages
	I(bias_DAC) <+ -I_bias_DAC;
    I(bias_CMFB) <+ -I_bias_CMFB;

  end

endmodule
