//Verilog-AMS HDL for "IMP_AN_SIGNAL_GEN_GM", "Signal_Generator_Amplifier" "verilogams"

//Verilog-AMS HDL for "IMP_AN_SIGNAL_GEN_GM", "Signal_Generator_Amplifier" "verilogams"
/*
 *  Variable gain Transconductance Amplifier
 *  Author: Saul Rodriguez
 *  Date: 2015-06-09
 *
 *  Description:
 *  This is a differential variable GM stage provides 3 gains
 *  which are controlled by the digital inputs G1-G0:
 *  G1 G0  Gain
 *   0  0   11.11111 uS
 *   0  1   33.33333 uS
 *   1  1  100 uS
 */

`include "constants.vams"
`include "disciplines.vams"

module Signal_Generator_Amplifier_2_bak2( bias_in, G0_NEG, G1_NEG, G0, G1, IoutN,
IoutP, VIN_N, VIN_P, vdda, vddd, vssa, vssd, vsub );

  input vsub;
  input IoutP;
  input G0;
  input VIN_P;
  input VIN_N;
  input G1;
  input vssd;
  input vdda;
  input IoutN;
  output bias_in;
  inout G1_NEG;
  inout G0_NEG;
  input vssa;
  input vddd;

/*
parameter real gm = 0.001 ;
parameter real vcm = 0.9 ;
parameter real GM = 0.001 ;
parameter real I_bias_DAC = 2e-06 ;
parameter real I_bias_CMFB = 5e-07 ;
parameter real Av = 20000 ;
parameter real GM0 = 1.11111e-05 ;
parameter real alfa = 2 ;

*/

  logic G0,G1;
  electrical VIN_P, VIN_N, IoutN, IoutP, vssa;
  electrical bias_DAC,bias_CMFB;

//  parameter real GM = 1.0m; //Transconductance
  parameter real vcm = 0.9; //Common mode voltage
  parameter real Av = 20000; //DC voltage Gain
  //parameter real I_bias_DAC = 2u;
  //parameter real I_bias_CMFB = 0.5u;
  parameter real GM0 = 11.11111u;
  real GM; //Transconductance
  real Gout, Gout_se, vodif;

  integer analog_state = 0; // Used to communicate between dig and analog!

  // Digital control block
  always @(G0,G1)
  begin
	analog_state = 0;
	if (G0 == 1) begin
		analog_state = analog_state + 1;
	end
	if (G1 == 1) begin
		analog_state = analog_state + 2;
	end

	if (analog_state == 0)
		GM = GM0;
	else if (analog_state == 1)
		GM = 3*GM0;
	else if (analog_state == 3)
		GM = 9*GM0;

	Gout=GM/Av;  //Gout differential
	Gout_se = 2*Gout; //Gout single ended

  end

  // Analog block
  analog begin

	vodif = Av*V(VIN_P,VIN_N); // Differential gain (DC)
	//Amplifier Ouput current

	I(IoutP,vssa) <+ (V(IoutP,vssa)-(vcm+vodif/2))*Gout_se;
	I(IoutN,vssa) <+ (V(IoutN,vssa)-(vcm-vodif/2))*Gout_se;

	//Biasing for other stages
	//I(bias_DAC) <+ -I_bias_DAC;
    //I(bias_CMFB) <+ -I_bias_CMFB;

  end

endmodule
