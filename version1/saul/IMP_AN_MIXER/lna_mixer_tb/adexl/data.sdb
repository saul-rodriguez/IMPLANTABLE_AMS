ADE simulation setup
Run mode: Single Run, Sweeps and Corners
Tests:
  IMP_AN_MIXER:lna_mixer_tb:1: IMP_AN_MIXER/lna_mixer_tb/config, simulator ams
Global variables:
  FLO = 2k
  IQCTRL = 0
  Amp = 50m
  Freq = 2K
  Phase = 0
