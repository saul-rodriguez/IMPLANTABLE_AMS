ADE simulation setup
Run mode: Single Run, Sweeps and Corners
Tests:
  IMP_AN_BIAS:current_mirror2_tb:1: IMP_AN_BIAS/current_mirror2_tb/config, simulator spectre
