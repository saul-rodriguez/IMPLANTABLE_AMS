ADE simulation setup
Run mode: Single Run, Sweeps and Corners
Tests:
  IMP_AN_SIGNAL_GEN:Signal_Generator_no_DAC_tb:1 (off): IMP_AN_SIGNAL_GEN/Signal_Generator_no_DAC_tb/config, simulator spectre
    Outputs: (VDC("/VOUTP") - VDC("/VOUTN")); phaseDeg(IF("/R0/PLUS"))
  IMP_AN_SIGNAL_GEN:Signal_Generator_no_DAC_tb:1:1: IMP_AN_SIGNAL_GEN/Signal_Generator_no_DAC_tb/config, simulator spectre
    Outputs: (VDC("/VOUTP") - VDC("/VOUTN")); phaseDeg(IF("/R0/PLUS"))
Global variables:
  CPAD = 1p
  DC_IN = 0
  G0 = 1.8
  G1 = 1.8
  G2 = 0
  G3 = 0
  R_DUT = 1k
  VAC_CM = 1
  VCM_PULSE = 0
  VDC_CM = 900m
  VDD_PULSE = 0
  VIN_AC = 0
  VIN_PULSE = 0
  Vsupply = 1.8
