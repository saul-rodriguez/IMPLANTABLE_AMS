ADE simulation setup
Run mode: Single Run, Sweeps and Corners
Tests:
  IMP_AN_SIGNAL_GEN:Signal_Generator_no_DAC_tb:1 (off): IMP_AN_SIGNAL_GEN/Signal_Generator_no_DAC_tb/schematic, simulator spectre
    Outputs: OFFSET; deriv(IS("/R0/PLUS")); (VT("/VOUTP") - VT("/VOUTN")); phaseDeg(IF("/R0/PLUS"))
  IMP_AN_SIGNAL_GEN:Signal_Generator_no_DAC_tb:2: IMP_AN_SIGNAL_GEN/Signal_Generator_no_DAC_tb/schematic, simulator spectre
    Outputs: (VT("/VOUTP") - VT("/VOUTN"))
  IMP_AN_SIGNAL_GEN:Signal_Generator_no_DAC_tb:1:1 (off): IMP_AN_SIGNAL_GEN/Signal_Generator_no_DAC_tb/schematic, simulator spectre
    Outputs: OFFSET; deriv(IS("/R0/PLUS")); (VT("/VOUTP") - VT("/VOUTN")); phaseDeg(IF("/R0/PLUS"))
Global variables:
  DC_IN = 0
  G0 = 1.8
  G1 = 1.8
  G2 = 0
  G3 = 0
  VAC_CM = 0
  VCM_PULSE = 10m
  VDC_CM = 900m
  VIN_AC = 1
  VIN_PULSE = 0
  R_DUT = 10000
  CPAD = 2p
  CC = 0.25p
  CMCC = 70p
  CMRES = 20k
  VCMFB_PULSE = 0
  VDD_PULSE = 0
  Vsupply = 1.8
Corners (all switched off):
  model folders: /pkg/AMS411/spectre/h18
  every corner: /pkg/AMS411/spectre/h18/mcparams.scs, /pkg/AMS411/spectre/h18/design.scs[noitm], /pkg/AMS411/spectre/h18/bip.scs[biptm], /pkg/AMS411/spectre/h18/esddi.scs[esdditm]
  C0_0: res.scs[reswp], cap.scs[capwp], cmos53.scs[cmosfff]
  C0_1: res.scs[resws], cap.scs[capwp], cmos53.scs[cmosfff]
  C0_2: res.scs[reswp], cap.scs[capws], cmos53.scs[cmosfff]
  C0_3: res.scs[resws], cap.scs[capws], cmos53.scs[cmosfff]
  C0_4: res.scs[reswp], cap.scs[capwp], cmos53.scs[cmosssf]
  C0_5: res.scs[resws], cap.scs[capwp], cmos53.scs[cmosssf]
  C0_6: res.scs[reswp], cap.scs[capws], cmos53.scs[cmosssf]
  C0_7: res.scs[resws], cap.scs[capws], cmos53.scs[cmosssf]
  C0_8: res.scs[reswp], cap.scs[capwp], cmos53.scs[cmoswo]
  C0_9: res.scs[resws], cap.scs[capwp], cmos53.scs[cmoswo]
  C0_10: res.scs[reswp], cap.scs[capws], cmos53.scs[cmoswo]
  C0_11: res.scs[resws], cap.scs[capws], cmos53.scs[cmoswo]
  C0_12: res.scs[reswp], cap.scs[capwp], cmos53.scs[cmoswz]
  C0_13: res.scs[resws], cap.scs[capwp], cmos53.scs[cmoswz]
  C0_14: res.scs[reswp], cap.scs[capws], cmos53.scs[cmoswz]
  C0_15: res.scs[resws], cap.scs[capws], cmos53.scs[cmoswz]
