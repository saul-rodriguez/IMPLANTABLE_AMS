ADE simulation setup
Run mode: Monte Carlo Sampling
Tests:
  IMP_AN_SIGNAL_GEN:Signal_Generator_no_DAC_tb:1 (off): IMP_AN_SIGNAL_GEN/Signal_Generator_no_DAC_tb/schematic, simulator spectre
    Outputs: OFFSET; deriv(IS("/R0/PLUS")); (VT("/VOUTP") - VT("/VOUTN")); phaseDeg(IF("/R0/PLUS"))
  IMP_AN_SIGNAL_GEN:Signal_Generator_no_DAC_tb:2 (off): IMP_AN_SIGNAL_GEN/Signal_Generator_no_DAC_tb/schematic, simulator spectre
    Outputs: (VT("/VOUTP") - VT("/VOUTN"))
  IMP_AN_SIGNAL_GEN:Signal_Generator_no_DAC_tb:1:1: IMP_AN_SIGNAL_GEN/Signal_Generator_no_DAC_tb/schematic, simulator spectre
    Outputs: OFFSET; deriv(IS("/R0/PLUS")); (VT("/VOUTP") - VT("/VOUTN")); phaseDeg(IF("/R0/PLUS"))
Global variables:
  DC_IN = 0
  G0 = 1.8
  G1 = 1.8
  G2 = 0
  G3 = 0
  VAC_CM = 0
  VCM_PULSE = 0
  VDC_CM = 900m
  VIN_AC = 1
  VIN_PULSE = 0
  R_DUT = 1M
  CPAD = 1p
  CC = 0.25p
  CMCC = 70p
  CMRES = 20k
  VCMFB_PULSE = 0
  VDD_PULSE = 0
Monte Carlo Sampling options: mcmethod=all, mcnumpoints=200
