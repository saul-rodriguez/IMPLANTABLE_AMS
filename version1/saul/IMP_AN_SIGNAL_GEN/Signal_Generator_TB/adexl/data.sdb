ADE simulation setup
Run mode: Single Run, Sweeps and Corners
Tests:
  IMP_AN_SIGNAL_GEN:Signal_Generator_TB:1: IMP_AN_SIGNAL_GEN/Signal_Generator_TB/config, simulator ams
Global variables:
  CLOCKWIDTH = 50
  CMFB_VAC = 0
  STEPNUM = 1
