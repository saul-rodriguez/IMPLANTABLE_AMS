ADE simulation setup
Run mode: Single Run, Sweeps and Corners
Tests:
  IMP_AN_SIGNAL_GEN:Signal_Generator_tb:1: IMP_AN_SIGNAL_GEN/Signal_Generator_tb/config, simulator ams
    Outputs: (VT("/VOUT_P") - VT("/VOUT_N"))
Global variables:
  CLOCKWIDTH = 15.625
  CMFB_VAC = 0
  PULSE_CMFB = 0
  STEPNUM = 0
  RL = 1k
  CPAD = 3p
  G0 = 1.8
  G1 = 1.8
  G2 = 1.8
  G3 = 1.8
