ADE simulation setup
Run mode: Monte Carlo Sampling
Tests:
  IMP_AN_SIGNAL_GEN:Signal_Generator_tb:1: IMP_AN_SIGNAL_GEN/Signal_Generator_tb/config, simulator ams
    Outputs: VOUT_DIF
Global variables:
  CLOCKWIDTH = 16000
  CMFB_VAC = 0
  PULSE_CMFB = 0
  STEPNUM = 0
  RL = 333k
  CPAD = 3p
  G0 = 0
  G1 = 0
  G2 = 1.8
  G3 = 0
Corners (all switched off):
  model folders: /pkg/AMS/spectre/h18/soac
  every corner: /pkg/AMS/spectre/h18/soac/mcparams.scs, /pkg/AMS/spectre/h18/soac/design.scs[noitm], /pkg/AMS/spectre/h18/soac/bip.scs[biptm], /pkg/AMS/spectre/h18/soac/esddi.scs[esdditm]
  C0_0_0_0: res.scs[reswp], cap.scs[capwp], cmos53.scs[cmosfff]
  C0_0_0_1: res.scs[resws], cap.scs[capwp], cmos53.scs[cmosfff]
  C0_0_0_2: res.scs[reswp], cap.scs[capws], cmos53.scs[cmosfff]
  C0_0_0_3: res.scs[resws], cap.scs[capws], cmos53.scs[cmosfff]
  C0_0_0_4: res.scs[reswp], cap.scs[capwp], cmos53.scs[cmosssf]
  C0_0_0_5: res.scs[resws], cap.scs[capwp], cmos53.scs[cmosssf]
  C0_0_0_6: res.scs[reswp], cap.scs[capws], cmos53.scs[cmosssf]
  C0_0_0_7: res.scs[resws], cap.scs[capws], cmos53.scs[cmosssf]
  C0_0_0_8: res.scs[reswp], cap.scs[capwp], cmos53.scs[cmoswo]
  C0_0_0_9: res.scs[resws], cap.scs[capwp], cmos53.scs[cmoswo]
  C0_0_0_10: res.scs[reswp], cap.scs[capws], cmos53.scs[cmoswo]
  C0_0_0_11: res.scs[resws], cap.scs[capws], cmos53.scs[cmoswo]
  C0_0_0_12: res.scs[reswp], cap.scs[capwp], cmos53.scs[cmoswz]
  C0_0_0_13: res.scs[resws], cap.scs[capwp], cmos53.scs[cmoswz]
  C0_0_0_14: res.scs[reswp], cap.scs[capws], cmos53.scs[cmoswz]
  C0_0_0_15: res.scs[resws], cap.scs[capws], cmos53.scs[cmoswz]
Monte Carlo Sampling options: mcmethod=all, mcnumpoints=200
