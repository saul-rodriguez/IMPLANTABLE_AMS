ADE simulation setup
Run mode: Single Run, Sweeps and Corners
Tests:
  IMP_AN_SIGNAL_GEN:Signal_Generator_tb:1: IMP_AN_SIGNAL_GEN/Signal_Generator_tb/config, simulator ams
    Outputs: (VT("/VOUT_P") - VT("/VOUT_N"))
Global variables:
  CLOCKWIDTH = 1000
  CMFB_VAC = 0
  PULSE_CMFB = 0
  STEPNUM = 0
  RL = 1M
