ADE simulation setup
Run mode: Single Run, Sweeps and Corners
Tests:
  IMP_AN_SIGNAL_GEN:Signal_Generator_tb:1: IMP_AN_SIGNAL_GEN/Signal_Generator_tb/config, simulator ams
    Outputs: CMV; OUT_CM
Global variables:
  CLOCKWIDTH = 15625
  CMFB_VAC = 0
  CPAD = 1p
  G0 = 0
  G1 = 0
  G2 = 0
  G3 = 0
  PULSE_CMFB = 0
  RL = 10k
  STEPNUM = 0
  VDD_PULSE = 0
  Vsupply = 1.8
  G0_PULSE = 1.8
  G1_PULSE = 1.8
  CE = 1
Corners (all switched off):
  model folders: /pkg/AMS411/spectre/h18/soac
  every corner: /pkg/AMS411/spectre/h18/soac/mcparams.scs, /pkg/AMS411/spectre/h18/soac/design.scs[noitm], /pkg/AMS411/spectre/h18/soac/bip.scs[biptm], /pkg/AMS411/spectre/h18/soac/esddi.scs[esdditm]
  C0_0: res.scs[reswp], cap.scs[capwp], cmos53.scs[cmosfff]
  C0_1: res.scs[resws], cap.scs[capwp], cmos53.scs[cmosfff]
  C0_2: res.scs[reswp], cap.scs[capws], cmos53.scs[cmosfff]
  C0_3: res.scs[resws], cap.scs[capws], cmos53.scs[cmosfff]
  C0_4: res.scs[reswp], cap.scs[capwp], cmos53.scs[cmosssf]
  C0_5: res.scs[resws], cap.scs[capwp], cmos53.scs[cmosssf]
  C0_6: res.scs[reswp], cap.scs[capws], cmos53.scs[cmosssf]
  C0_7: res.scs[resws], cap.scs[capws], cmos53.scs[cmosssf]
  C0_8: res.scs[reswp], cap.scs[capwp], cmos53.scs[cmoswo]
  C0_9: res.scs[resws], cap.scs[capwp], cmos53.scs[cmoswo]
  C0_10: res.scs[reswp], cap.scs[capws], cmos53.scs[cmoswo]
  C0_11: res.scs[resws], cap.scs[capws], cmos53.scs[cmoswo]
  C0_12: res.scs[reswp], cap.scs[capwp], cmos53.scs[cmoswz]
  C0_13: res.scs[resws], cap.scs[capwp], cmos53.scs[cmoswz]
  C0_14: res.scs[reswp], cap.scs[capws], cmos53.scs[cmoswz]
  C0_15: res.scs[resws], cap.scs[capws], cmos53.scs[cmoswz]
