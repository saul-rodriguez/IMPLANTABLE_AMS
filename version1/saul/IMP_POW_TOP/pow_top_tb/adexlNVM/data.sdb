ADE simulation setup
Run mode: Single Run, Sweeps and Corners
Tests:
  IMP_POW_TOP:pow_top_tb:1: IMP_POW_TOP/pow_top_tb/config, simulator spectre
Global variables:
  TX_DATA = 0
  VIN_AC = 0
  VIN_DC = 0
  VIN_PULSE = 0
  FREQ = 1000k
  VIN_AMP = 4
  C_REC = 2u
  AM_INDEX = 0.1
