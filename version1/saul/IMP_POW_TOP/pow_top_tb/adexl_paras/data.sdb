ADE simulation setup
Run mode: Single Run, Sweeps and Corners
Tests:
  IMP_POW_TOP:pow_top_tb:1: IMP_POW_TOP/pow_top_tb/config, simulator spectre
Global variables:
  AM_INDEX = 0.1
  C_REC = 10u
  FREQ = 10k
  RL = 1k
  TX_DATA = 0
  VIN_AMP = 0
  VIN_DC = 0
  VIN_PULSE = 3
