ADE simulation setup
Run mode: Single Run, Sweeps and Corners
Tests:
  IMP_POW_TOP:pow_top_tb:1: IMP_POW_TOP/pow_top_tb/config, simulator spectre
Global variables:
  TX_DATA = 0
  VIN_AC = 0
  VIN_DC = 5
  VIN_PULSE = 0
Corners:
  model folders: /afs/ict.kth.se/proj/ektlab/PDK/AMS/spectre/h18/soac
  C0 (off): mcparams.scs, design.scs[noitm], res.scs[reswp resws], cap.scs[capwp capws], bip.scs[biptm], esddi.scs[esdditm], cmos53.scs[cmoswo cmoswz cmosfff cmosssf]
