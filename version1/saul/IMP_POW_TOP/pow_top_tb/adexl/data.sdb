ADE simulation setup
Run mode: Single Run, Sweeps and Corners
Tests:
  IMP_POW_TOP:pow_top_tb:2: IMP_POW_TOP/pow_top_tb/config, simulator spectre
  IMP_POW_TOP:pow_top_tb:1 (off): IMP_POW_TOP/pow_top_tb/config, simulator spectre
Global variables:
  TX_DATA = 0
  VIN_AC = 0
  VIN_DC = 3.2
  VIN_PULSE = 0
  AM_INDEX = 0.1
  C_REC = 20u
  FREQ = 100k
  VIN_AMP = 0
  RL = 1k
Corners (all switched off):
  model folders: /pkg/AMS411/spectre/h18/soac
  every corner: /pkg/AMS411/spectre/h18/soac/mcparams.scs, /pkg/AMS411/spectre/h18/soac/design.scs[noitm], /pkg/AMS411/spectre/h18/soac/esddi.scs[esdditm]
  C0_0: res.scs[reswp], cap.scs[capwp], bip.scs[biphs], cmos53.scs[cmosfff]
  C0_1: res.scs[resws], cap.scs[capwp], bip.scs[biphs], cmos53.scs[cmosfff]
  C0_2: res.scs[reswp], cap.scs[capws], bip.scs[biphs], cmos53.scs[cmosfff]
  C0_3: res.scs[resws], cap.scs[capws], bip.scs[biphs], cmos53.scs[cmosfff]
  C0_4: res.scs[reswp], cap.scs[capwp], bip.scs[biplb], cmos53.scs[cmosfff]
  C0_5: res.scs[resws], cap.scs[capwp], bip.scs[biplb], cmos53.scs[cmosfff]
  C0_6: res.scs[reswp], cap.scs[capws], bip.scs[biplb], cmos53.scs[cmosfff]
  C0_7: res.scs[resws], cap.scs[capws], bip.scs[biplb], cmos53.scs[cmosfff]
  C0_8: res.scs[reswp], cap.scs[capwp], bip.scs[biphs], cmos53.scs[cmosssf]
  C0_9: res.scs[resws], cap.scs[capwp], bip.scs[biphs], cmos53.scs[cmosssf]
  C0_10: res.scs[reswp], cap.scs[capws], bip.scs[biphs], cmos53.scs[cmosssf]
  C0_11: res.scs[resws], cap.scs[capws], bip.scs[biphs], cmos53.scs[cmosssf]
  C0_12: res.scs[reswp], cap.scs[capwp], bip.scs[biplb], cmos53.scs[cmosssf]
  C0_13: res.scs[resws], cap.scs[capwp], bip.scs[biplb], cmos53.scs[cmosssf]
  C0_14: res.scs[reswp], cap.scs[capws], bip.scs[biplb], cmos53.scs[cmosssf]
  C0_15: res.scs[resws], cap.scs[capws], bip.scs[biplb], cmos53.scs[cmosssf]
  C0_16: res.scs[reswp], cap.scs[capwp], bip.scs[biphs], cmos53.scs[cmoswo]
  C0_17: res.scs[resws], cap.scs[capwp], bip.scs[biphs], cmos53.scs[cmoswo]
  C0_18: res.scs[reswp], cap.scs[capws], bip.scs[biphs], cmos53.scs[cmoswo]
  C0_19: res.scs[resws], cap.scs[capws], bip.scs[biphs], cmos53.scs[cmoswo]
  C0_20: res.scs[reswp], cap.scs[capwp], bip.scs[biplb], cmos53.scs[cmoswo]
  C0_21: res.scs[resws], cap.scs[capwp], bip.scs[biplb], cmos53.scs[cmoswo]
  C0_22: res.scs[reswp], cap.scs[capws], bip.scs[biplb], cmos53.scs[cmoswo]
  C0_23: res.scs[resws], cap.scs[capws], bip.scs[biplb], cmos53.scs[cmoswo]
  C0_24: res.scs[reswp], cap.scs[capwp], bip.scs[biphs], cmos53.scs[cmoswz]
  C0_25: res.scs[resws], cap.scs[capwp], bip.scs[biphs], cmos53.scs[cmoswz]
  C0_26: res.scs[reswp], cap.scs[capws], bip.scs[biphs], cmos53.scs[cmoswz]
  C0_27: res.scs[resws], cap.scs[capws], bip.scs[biphs], cmos53.scs[cmoswz]
  C0_28: res.scs[reswp], cap.scs[capwp], bip.scs[biplb], cmos53.scs[cmoswz]
  C0_29: res.scs[resws], cap.scs[capwp], bip.scs[biplb], cmos53.scs[cmoswz]
  C0_30: res.scs[reswp], cap.scs[capws], bip.scs[biplb], cmos53.scs[cmoswz]
  C0_31: res.scs[resws], cap.scs[capws], bip.scs[biplb], cmos53.scs[cmoswz]
