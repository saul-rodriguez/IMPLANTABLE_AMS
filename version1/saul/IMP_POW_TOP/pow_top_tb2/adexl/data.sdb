ADE simulation setup
Run mode: Single Run, Sweeps and Corners
Tests:
  IMP_POW_TOP:pow_top_tb2:1: IMP_POW_TOP/pow_top_tb2/config, simulator spectre
Global variables:
  AM_INDEX = 0
  C_REC = 10u
  FREQ = 10M
  RL = 1k
  TX_DATA = 0
  VIN_AMP = 0
  VIN_DC = 3
  VIN_PULSE = 0
