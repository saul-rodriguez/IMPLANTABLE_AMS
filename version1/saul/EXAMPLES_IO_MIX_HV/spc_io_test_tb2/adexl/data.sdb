ADE simulation setup
Run mode: Single Run, Sweeps and Corners
Tests:
  ALL_TESTS:spc_io_test_tb2:1: EXAMPLES_IO_MIX_HV/spc_io_test_tb2/config, simulator ams
Global variables:
  VDC = 1.8
  VDC_A = 1.75
