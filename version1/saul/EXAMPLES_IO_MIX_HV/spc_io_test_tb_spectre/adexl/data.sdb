ADE simulation setup
Run mode: Single Run, Sweeps and Corners
Tests:
  EXAMPLES_IO_MIX_HV:spc_io_test_tb_spectre:1: EXAMPLES_IO_MIX_HV/spc_io_test_tb_spectre/config, simulator spectre
Global variables:
  VDC = 1.8
