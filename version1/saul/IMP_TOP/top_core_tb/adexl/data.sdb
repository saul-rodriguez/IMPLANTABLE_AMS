ADE simulation setup
Run mode: Single Run, Sweeps and Corners
Tests:
  IMP_TOP:top_core_tb:1: IMP_TOP/top_core_tb/config, simulator ams
    Outputs: VIN; VOUT; AMP; PHA
Global variables:
  AM_INDEX = 0.1
  C_REG = 1u
  CAP_OFF = 1n
  CAP_PAD = 600f
  CAP_TIA = 4.5n
  CMFB_VAC = 0
  FREQ = 1k
  PULSE_CMFB_LNA = 0
  RL = 500
  TX_DELAY = 1
  VIN_AMP = 4
  VIN_DC = 0
  VIN_AC = 0
  AMPLITUDE = 0.1
  VOFFSET = 1.4
  CMFB_AC = 0
  CMFB_PULSE_TIA = 0
