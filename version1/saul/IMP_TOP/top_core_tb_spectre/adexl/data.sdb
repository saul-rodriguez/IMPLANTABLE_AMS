ADE simulation setup
Run mode: Single Run, Sweeps and Corners
Tests:
  IMP_TOP:top_core_tb_spectre:1: IMP_TOP/top_core_tb_spectre/config, simulator spectre
Global variables:
  AM_INDEX = 0
  BONDWIRE = 3n
  C_REG = 20u
  CAP_OFF = 0.5n
  CAP_PAD = 800f
  CAP_TIA = 1.5n
  fmax = 60M
  fref = 500k
  FREQ = 10M
  RL = 1k
  TX_DELAY = 1m
  VDD_PULSE = 0
  VIN_AMP = 0
  VIN_DC = 4
