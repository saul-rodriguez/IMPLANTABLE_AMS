ADE simulation setup
Run mode: Single Run, Sweeps and Corners
Tests:
  IMP_TOP:top_imp_sensor_tb_spectre:1: IMP_TOP/top_imp_sensor_tb_spectre/config, simulator spectre
Global variables:
  CAP_OFF = 0.5n
  CAP_PAD = 800f
  CAP_TIA = 1n
  fmax = 60M
  RL = 100
  fref = 500k
