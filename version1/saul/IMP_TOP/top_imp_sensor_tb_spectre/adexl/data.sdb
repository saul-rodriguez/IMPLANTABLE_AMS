ADE simulation setup
Run mode: Single Run, Sweeps and Corners
Tests:
  IMP_TOP:top_imp_sensor_tb_spectre:1 (off): IMP_TOP/top_imp_sensor_tb_spectre/config, simulator spectre
    Outputs: (VT("/VOUTP") - VT("/VOUTN")); (VT("/VTIA_P") - VT("/VTIA_N")); copy1; copy2
  IMP_TOP:top_imp_sensor_tb_spectre:1:1: IMP_TOP/top_imp_sensor_tb_spectre/config, simulator spectre
    Outputs: copy1; copy2
Global variables:
  CAP_OFF = 0.5n
  CAP_PAD = 800f
  CAP_TIA = 1n
  fmax = 60M
  RL = 1000
  fref = 500k
  BONDWIRE = 3n
