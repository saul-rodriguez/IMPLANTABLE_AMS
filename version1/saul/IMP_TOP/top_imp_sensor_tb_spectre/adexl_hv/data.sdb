ADE simulation setup
Run mode: Single Run, Sweeps and Corners
Tests:
  IMP_TOP:top_imp_sensor_tb:1: IMP_TOP/top_imp_sensor_tb/config, simulator ams
    Outputs: VOUT; sqrt(((value((VT("/VOUTP") - VT("/VOUTN")) 0.0099)**2) + (value((VT("/VOUTP") - VT("/VOUTN")) 0.0199)**2))); calcVal("" "IMP_TOP:top_imp_sensor_tb:1"); VOUT_DEM; sqrt(((value((VT("/VOUTP") - VT("/VOUTN")) 0.99)**2) + (value((VT("/VOUTP") - VT("/VOUTN")) 0.199)**2))); AMP; PHA
Global variables:
  CAP_OFF = 1.5n
  CAP_PAD = 800f
  CAP_TIA = 1n
  RL = 10k
  fmax = 50M
  LBOND = 2n
