ADE simulation setup
Run mode: Single Run, Sweeps and Corners
Tests:
  IMP_TOP:top_core_tb_spectre:1: IMP_TOP/top_ring_core_tb_spectre/config, simulator spectre
Global variables:
  AM_INDEX = 0
  BONDWIRE = 3n
  C_REG = 20u
  CAP_OFF = 0.5n
  CAP_PAD = 800f
  CAP_TIA = 1.5n
  fmax = 60M
  fref = 500k
  FREQ = 10M
  RL = 1k
  TX_DELAY = 1m
  VDD_PULSE = 0
  VIN_AMP = 0
  VIN_DC = 4
Corners (all switched off):
  model folders: /pkg/AMS411/spectre/h18
  every corner: /pkg/AMS411/spectre/h18/mcparams.scs, /pkg/AMS411/spectre/h18/design.scs[noitm], /pkg/AMS411/spectre/h18/bip.scs[biptm], /pkg/AMS411/spectre/h18/esddi.scs[esdditm]
  C0_0: res.scs[reswp], cap.scs[capwp], cmos53.scs[cmosfff]
  C0_1: res.scs[resws], cap.scs[capwp], cmos53.scs[cmosfff]
  C0_2: res.scs[reswp], cap.scs[capws], cmos53.scs[cmosfff]
  C0_3: res.scs[resws], cap.scs[capws], cmos53.scs[cmosfff]
  C0_4: res.scs[reswp], cap.scs[capwp], cmos53.scs[cmosssf]
  C0_5: res.scs[resws], cap.scs[capwp], cmos53.scs[cmosssf]
  C0_6: res.scs[reswp], cap.scs[capws], cmos53.scs[cmosssf]
  C0_7: res.scs[resws], cap.scs[capws], cmos53.scs[cmosssf]
  C0_8: res.scs[reswp], cap.scs[capwp], cmos53.scs[cmoswo]
  C0_9: res.scs[resws], cap.scs[capwp], cmos53.scs[cmoswo]
  C0_10: res.scs[reswp], cap.scs[capws], cmos53.scs[cmoswo]
  C0_11: res.scs[resws], cap.scs[capws], cmos53.scs[cmoswo]
  C0_12: res.scs[reswp], cap.scs[capwp], cmos53.scs[cmoswz]
  C0_13: res.scs[resws], cap.scs[capwp], cmos53.scs[cmoswz]
  C0_14: res.scs[reswp], cap.scs[capws], cmos53.scs[cmoswz]
  C0_15: res.scs[resws], cap.scs[capws], cmos53.scs[cmoswz]
