ADE simulation setup
Run mode: Single Run, Sweeps and Corners
Tests:
  IMP_TOP:top_tb:1: IMP_TOP/top_tb/config, simulator ams
    Outputs: VIN; VOUT; VTIA
Global variables:
  CAP_OFF = 1.5n
  CAP_TIA = 4.7n
  CMFB_VAC = 0
  PULSE_CMFB = 0
  RL = 100
  PULSE_CMFB_LNA = 0
  CMFB_AC = 0
  CMFB_PULSE_TIA = 0
  CAP_PAD = 800f
