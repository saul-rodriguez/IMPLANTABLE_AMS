ADE simulation setup
Run mode: Single Run, Sweeps and Corners
Tests:
  IMP_TOP:top_tb:1: IMP_TOP/top_tb/config, simulator ams
    Outputs: VDUT; VOUT
Global variables:
  CAP_OFF = 0.5n
  CAP_TIA = 1.5n
  CAP_PAD = 900f
  fmax = 60M
  RL = 10k
