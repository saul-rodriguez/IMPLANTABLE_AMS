ADE simulation setup
Run mode: Single Run, Sweeps and Corners
Tests:
  IMP_TOP:top_imp_sensor_tb:1: IMP_TOP/top_imp_sensor_tb/config, simulator ams
    Outputs: VOUT
Global variables:
  CAP_OFF = 1.5n
  CAP_PAD = 800f
  CAP_TIA = 1n
  RL = 10k
