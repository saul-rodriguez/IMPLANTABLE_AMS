ADE simulation setup
Run mode: Single Run, Sweeps and Corners
Tests:
  IMP_TOP:top_tb:1: IMP_TOP/top_tb/config, simulator ams
Global variables:
  CAP_OFF = 1n
  CAP_TIA = 15n
  CMFB_AC = 0
  CMFB_PULSE_TIA = 0
  CMFB_VAC = 0
  PULSE_CMFB = 0
  PULSE_CMFB_LNA = 0
