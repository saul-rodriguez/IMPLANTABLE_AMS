//Verilog-AMS HDL for "IMP_DAC", "RDAC32" "verilogams"

`include "constants.vams"
`include "disciplines.vams"

module RDAC32_bak( VON, VOP, bias, vdda, vssa, vsub, P );

  input  [16:0] P;
  inout VOP;
  inout vsub;
  inout vdda;
  inout bias;
  inout VON;
  inout vssa;

  logic [16:0] P;
  electrical VOP,VON, bias;

  parameter real vcm = 0.9; //Common mode voltage
  real amp = 0;
  real vop, von;
  real bias_i;

  // Digital block
 // Digital control block
always @(P)
begin
	case(P)
		17'b0_0000_0000_0000_0001: amp = 0;
		17'b0_0000_0000_0000_0010: amp = 0.0098;
		17'b0_0000_0000_0000_0100: amp = 0.0191;
		17'b0_0000_0000_0000_1000: amp = 0.0278;
		17'b0_0000_0000_0001_0000: amp = 0.0354;
		17'b0_0000_0000_0010_0000: amp = 0.0416;
		17'b0_0000_0000_0100_0000: amp = 0.0462;
		17'b0_0000_0000_1000_0000: amp = 0.0490;
		17'b0_0000_0001_0000_0000: amp = 0.0500;
		17'b0_0000_0000_1000_0000: amp = 0.0490;
		17'b0_0000_0000_0100_0000: amp = 0.0462;
		17'b0_0000_0000_0010_0000: amp = 0.0416;
		17'b0_0000_0000_0001_0000: amp = 0.0354;
		17'b0_0000_0000_0000_1000: amp = 0.0278;
		17'b0_0000_0000_0000_0100: amp = 0.0191;
		17'b0_0000_0000_0000_0010: amp = 0.0098;
		17'b0_0000_0000_0000_0001: amp = 0.0000;
        17'b0_0000_0010_0000_0000: amp = -0.0098;
        17'b0_0000_0100_0000_0000: amp = -0.0191;
        17'b0_0000_1000_0000_0000: amp = -0.0278;
        17'b0_0001_0000_0000_0000: amp = -0.0354;
        17'b0_0010_0000_0000_0000: amp = -0.0416;
        17'b0_0100_0000_0000_0000: amp = -0.0462;
        17'b0_1000_0000_0000_0000: amp = -0.0490;
        17'b1_0000_0000_0000_0000: amp = -0.0500;
        17'b0_1000_0000_0000_0000: amp = -0.0490;
        17'b0_0100_0000_0000_0000: amp = -0.0462;
        17'b0_0010_0000_0000_0000: amp = -0.0416;
        17'b0_0001_0000_0000_0000: amp = -0.0354;
        17'b0_0000_1000_0000_0000: amp = -0.0278;
        17'b0_0000_0100_0000_0000: amp = -0.0191;
        17'b0_0000_0010_0000_0000: amp = -0.0098;
		default: amp = 0;
	endcase

end

  // Analog block
analog begin
	bias_i = -I(bias)/2e-6;

	vop = vcm + amp*bias_i;
    von = vcm - amp*bias_i;

	V(VON) <+ vop;
	V(VOP) <+ von;

end

endmodule
