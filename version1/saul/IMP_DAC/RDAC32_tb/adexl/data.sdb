ADE simulation setup
Run mode: Single Run, Sweeps and Corners
Tests:
  IMP_DAC:RDAC32_tb:1: IMP_DAC/RDAC32_tb/config, simulator ams
Global variables:
  CLOCKWIDTH = 5
  STEPNUM = 1
