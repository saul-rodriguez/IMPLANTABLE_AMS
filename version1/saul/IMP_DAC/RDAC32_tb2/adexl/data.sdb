ADE simulation setup
Run mode: Single Run, Sweeps and Corners
Tests:
  IMP_DAC:RDAC32_tb2:1: IMP_DAC/RDAC32_tb2/config, simulator ams
    Outputs: (VT("/VOP") - VT("/VON"))
Global variables:
  CLOCKWIDTH = 16
  I_BIAS = 2u
  STEPNUM = 0
