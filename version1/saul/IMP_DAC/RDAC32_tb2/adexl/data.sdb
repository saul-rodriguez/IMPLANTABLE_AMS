ADE simulation setup
Run mode: Single Run, Sweeps and Corners
Tests:
  IMP_DAC:RDAC32_tb2:1: IMP_DAC/RDAC32_tb2/config, simulator ams
Global variables:
  CLOCKWIDTH = 50
  I_BIAS = 2u
  STEPNUM = 50
  CMFB_VAC = 0
  PULSE_CMFB = 0
