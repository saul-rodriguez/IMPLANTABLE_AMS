ADE simulation setup
Run mode: Single Run, Sweeps and Corners
Tests:
  IMP_DAC:RDAC32_tb2:1: IMP_DAC/RDAC32_tb2/config, simulator ams
Global variables:
  CLOCKWIDTH = 1000
  CMFB_VAC = 0
  I_BIAS = 2u
  PULSE_CMFB = 0
  STEPNUM = 0
