// VerilogA for IMP_DAC, my_res, veriloga

`include "constants.vams"
`include "disciplines.vams"

module my_res(P1, P2);
inout P1;
electrical P1;
inout P2;
electrical P2;

parameter real r=1 exclude 0;

analog begin
    I(P1,P2) <+ V(P1,P2)/r;
end

endmodule
