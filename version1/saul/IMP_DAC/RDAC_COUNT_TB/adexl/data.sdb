ADE simulation setup
Run mode: Single Run, Sweeps and Corners
Tests:
  IMP_DAC:RDAC_COUNT_TB:1 (off): IMP_DAC/RDAC_COUNT_TB/config, simulator ams
  IMP_DAC:RDAC_COUNT_TB:1:1 (off): IMP_DAC/RDAC_COUNT_TB/config_irun, simulator ams
  IMP_DAC:RDAC_COUNT_TB:2: IMP_DAC/RDAC_COUNT_TB/config_spectre, simulator spectre
