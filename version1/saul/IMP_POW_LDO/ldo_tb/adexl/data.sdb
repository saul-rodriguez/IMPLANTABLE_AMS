ADE simulation setup
Run mode: Single Run, Sweeps and Corners
Tests:
  IMP_POW_LDO:ldo_tb:1: IMP_POW_LDO/ldo_tb/schematic, simulator spectre
Global variables:
  VD_AC = 0
  VREF_AC = 1
  CL = 100p,1u,10u (off)
  RL = 10k,100k,1M (off)
  VREF = 1.2
  Vsupply = 3
