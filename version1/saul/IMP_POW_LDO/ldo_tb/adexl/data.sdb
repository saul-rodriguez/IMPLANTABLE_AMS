ADE simulation setup
Run mode: Monte Carlo Sampling
Tests:
  IMP_POW_LDO:ldo_tb:1 (off): IMP_POW_LDO/ldo_tb/schematic, simulator spectre
    Outputs: VF("/V_REG"); value(VF("/V_REG") 100); abs(value(VF("/V_REG") 100)); VDC("/V_REG")
  IMP_POW_LDO:ldo_tb:2: IMP_POW_LDO/ldo_tb/schematic, simulator spectre
Global variables:
  VD_AC = 1
  VREF_AC = 0
  CL = 10u
  RL = 5k
  VREF = 1.2
  Vsupply = 3
  VIN_PULSE = 0
  VD_PULSE = 100m
Monte Carlo Sampling options: mcmethod=all, mcnumpoints=200
