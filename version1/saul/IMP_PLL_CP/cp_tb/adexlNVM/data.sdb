ADE simulation setup
Run mode: Single Run, Sweeps and Corners
Tests:
  IMP_PLL_CP:cp_tb:1: IMP_PLL_CP/cp_tb/config, simulator ams
