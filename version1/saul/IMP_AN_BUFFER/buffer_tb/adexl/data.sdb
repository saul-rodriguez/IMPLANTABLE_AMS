ADE simulation setup
Run mode: Single Run, Sweeps and Corners
Tests:
  IMP_AN_BUFFER:buffer_tb:1 (off): IMP_AN_BUFFER/buffer_tb/config, simulator spectre
    Outputs: dB20(VF("/Vout")); value(VDC("/Vout") 0.9); value(VDC("/Vout") 1000); value(VF("/Vout") 1000)
  IMP_AN_BUFFER:buffer_tb:2: IMP_AN_BUFFER/buffer_tb/config, simulator spectre
Global variables:
  CL = 1p,10p,30p,300p
  IBIAS_STEP = 0
  RL = 100k,1M,10M,100M
  VDD_AC = 0
  VDD_STEP = 0
  VIN_AC = 1
  VIN_DC = 900m
  VIN_STEP = 50m
  Vsupply = 1.8
Corners (all switched off):
  model folders: /pkg/AMS/spectre/h18/soac
  every corner: /pkg/AMS/spectre/h18/soac/design.scs[noitm], /pkg/AMS/spectre/h18/soac/esddi.scs[esdditm], /pkg/AMS/spectre/h18/soac/bip.scs[biptm], /pkg/AMS/spectre/h18/soac/mcparams.scs
  corner_0: temperature=0; Vsupply=1.62; cap.scs[capwp], res.scs[reswp], cmos53.scs[cmosfff]
  corner_1: temperature=85; Vsupply=1.62; cap.scs[capwp], res.scs[reswp], cmos53.scs[cmosfff]
  corner_2: temperature=0; Vsupply=1.98; cap.scs[capwp], res.scs[reswp], cmos53.scs[cmosfff]
  corner_3: temperature=85; Vsupply=1.98; cap.scs[capwp], res.scs[reswp], cmos53.scs[cmosfff]
  corner_4: temperature=0; Vsupply=1.62; cap.scs[capws], res.scs[reswp], cmos53.scs[cmosfff]
  corner_5: temperature=85; Vsupply=1.62; cap.scs[capws], res.scs[reswp], cmos53.scs[cmosfff]
  corner_6: temperature=0; Vsupply=1.98; cap.scs[capws], res.scs[reswp], cmos53.scs[cmosfff]
  corner_7: temperature=85; Vsupply=1.98; cap.scs[capws], res.scs[reswp], cmos53.scs[cmosfff]
  corner_8: temperature=0; Vsupply=1.62; cap.scs[capwp], res.scs[resws], cmos53.scs[cmosfff]
  corner_9: temperature=85; Vsupply=1.62; cap.scs[capwp], res.scs[resws], cmos53.scs[cmosfff]
  corner_10: temperature=0; Vsupply=1.98; cap.scs[capwp], res.scs[resws], cmos53.scs[cmosfff]
  corner_11: temperature=85; Vsupply=1.98; cap.scs[capwp], res.scs[resws], cmos53.scs[cmosfff]
  corner_12: temperature=0; Vsupply=1.62; cap.scs[capws], res.scs[resws], cmos53.scs[cmosfff]
  corner_13: temperature=85; Vsupply=1.62; cap.scs[capws], res.scs[resws], cmos53.scs[cmosfff]
  corner_14: temperature=0; Vsupply=1.98; cap.scs[capws], res.scs[resws], cmos53.scs[cmosfff]
  corner_15: temperature=85; Vsupply=1.98; cap.scs[capws], res.scs[resws], cmos53.scs[cmosfff]
  corner_16: temperature=0; Vsupply=1.62; cap.scs[capwp], res.scs[reswp], cmos53.scs[cmosssf]
  corner_17: temperature=85; Vsupply=1.62; cap.scs[capwp], res.scs[reswp], cmos53.scs[cmosssf]
  corner_18: temperature=0; Vsupply=1.98; cap.scs[capwp], res.scs[reswp], cmos53.scs[cmosssf]
  corner_19: temperature=85; Vsupply=1.98; cap.scs[capwp], res.scs[reswp], cmos53.scs[cmosssf]
  corner_20: temperature=0; Vsupply=1.62; cap.scs[capws], res.scs[reswp], cmos53.scs[cmosssf]
  corner_21: temperature=85; Vsupply=1.62; cap.scs[capws], res.scs[reswp], cmos53.scs[cmosssf]
  corner_22: temperature=0; Vsupply=1.98; cap.scs[capws], res.scs[reswp], cmos53.scs[cmosssf]
  corner_23: temperature=85; Vsupply=1.98; cap.scs[capws], res.scs[reswp], cmos53.scs[cmosssf]
  corner_24: temperature=0; Vsupply=1.62; cap.scs[capwp], res.scs[resws], cmos53.scs[cmosssf]
  corner_25: temperature=85; Vsupply=1.62; cap.scs[capwp], res.scs[resws], cmos53.scs[cmosssf]
  corner_26: temperature=0; Vsupply=1.98; cap.scs[capwp], res.scs[resws], cmos53.scs[cmosssf]
  corner_27: temperature=85; Vsupply=1.98; cap.scs[capwp], res.scs[resws], cmos53.scs[cmosssf]
  corner_28: temperature=0; Vsupply=1.62; cap.scs[capws], res.scs[resws], cmos53.scs[cmosssf]
  corner_29: temperature=85; Vsupply=1.62; cap.scs[capws], res.scs[resws], cmos53.scs[cmosssf]
  corner_30: temperature=0; Vsupply=1.98; cap.scs[capws], res.scs[resws], cmos53.scs[cmosssf]
  corner_31: temperature=85; Vsupply=1.98; cap.scs[capws], res.scs[resws], cmos53.scs[cmosssf]
  corner_32: temperature=0; Vsupply=1.62; cap.scs[capwp], res.scs[reswp], cmos53.scs[cmoswo]
  corner_33: temperature=85; Vsupply=1.62; cap.scs[capwp], res.scs[reswp], cmos53.scs[cmoswo]
  corner_34: temperature=0; Vsupply=1.98; cap.scs[capwp], res.scs[reswp], cmos53.scs[cmoswo]
  corner_35: temperature=85; Vsupply=1.98; cap.scs[capwp], res.scs[reswp], cmos53.scs[cmoswo]
  corner_36: temperature=0; Vsupply=1.62; cap.scs[capws], res.scs[reswp], cmos53.scs[cmoswo]
  corner_37: temperature=85; Vsupply=1.62; cap.scs[capws], res.scs[reswp], cmos53.scs[cmoswo]
  corner_38: temperature=0; Vsupply=1.98; cap.scs[capws], res.scs[reswp], cmos53.scs[cmoswo]
  corner_39: temperature=85; Vsupply=1.98; cap.scs[capws], res.scs[reswp], cmos53.scs[cmoswo]
  corner_40: temperature=0; Vsupply=1.62; cap.scs[capwp], res.scs[resws], cmos53.scs[cmoswo]
  corner_41: temperature=85; Vsupply=1.62; cap.scs[capwp], res.scs[resws], cmos53.scs[cmoswo]
  corner_42: temperature=0; Vsupply=1.98; cap.scs[capwp], res.scs[resws], cmos53.scs[cmoswo]
  corner_43: temperature=85; Vsupply=1.98; cap.scs[capwp], res.scs[resws], cmos53.scs[cmoswo]
  corner_44: temperature=0; Vsupply=1.62; cap.scs[capws], res.scs[resws], cmos53.scs[cmoswo]
  corner_45: temperature=85; Vsupply=1.62; cap.scs[capws], res.scs[resws], cmos53.scs[cmoswo]
  corner_46: temperature=0; Vsupply=1.98; cap.scs[capws], res.scs[resws], cmos53.scs[cmoswo]
  corner_47: temperature=85; Vsupply=1.98; cap.scs[capws], res.scs[resws], cmos53.scs[cmoswo]
  corner_48: temperature=0; Vsupply=1.62; cap.scs[capwp], res.scs[reswp], cmos53.scs[cmoswz]
  corner_49: temperature=85; Vsupply=1.62; cap.scs[capwp], res.scs[reswp], cmos53.scs[cmoswz]
  corner_50: temperature=0; Vsupply=1.98; cap.scs[capwp], res.scs[reswp], cmos53.scs[cmoswz]
  corner_51: temperature=85; Vsupply=1.98; cap.scs[capwp], res.scs[reswp], cmos53.scs[cmoswz]
  corner_52: temperature=0; Vsupply=1.62; cap.scs[capws], res.scs[reswp], cmos53.scs[cmoswz]
  corner_53: temperature=85; Vsupply=1.62; cap.scs[capws], res.scs[reswp], cmos53.scs[cmoswz]
  corner_54: temperature=0; Vsupply=1.98; cap.scs[capws], res.scs[reswp], cmos53.scs[cmoswz]
  corner_55: temperature=85; Vsupply=1.98; cap.scs[capws], res.scs[reswp], cmos53.scs[cmoswz]
  corner_56: temperature=0; Vsupply=1.62; cap.scs[capwp], res.scs[resws], cmos53.scs[cmoswz]
  corner_57: temperature=85; Vsupply=1.62; cap.scs[capwp], res.scs[resws], cmos53.scs[cmoswz]
  corner_58: temperature=0; Vsupply=1.98; cap.scs[capwp], res.scs[resws], cmos53.scs[cmoswz]
  corner_59: temperature=85; Vsupply=1.98; cap.scs[capwp], res.scs[resws], cmos53.scs[cmoswz]
  corner_60: temperature=0; Vsupply=1.62; cap.scs[capws], res.scs[resws], cmos53.scs[cmoswz]
  corner_61: temperature=85; Vsupply=1.62; cap.scs[capws], res.scs[resws], cmos53.scs[cmoswz]
  corner_62: temperature=0; Vsupply=1.98; cap.scs[capws], res.scs[resws], cmos53.scs[cmoswz]
  corner_63: temperature=85; Vsupply=1.98; cap.scs[capws], res.scs[resws], cmos53.scs[cmoswz]
