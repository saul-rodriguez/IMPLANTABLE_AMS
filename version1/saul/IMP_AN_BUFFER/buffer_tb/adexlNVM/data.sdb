ADE simulation setup
Run mode: Single Run, Sweeps and Corners
Tests:
  IMP_AN_BUFFER:buffer_tb:1: IMP_AN_BUFFER/buffer_tb/config, simulator spectre
Global variables:
  CL = 40p
  IBIAS_STEP = 0
  RL = 1M
  VDD_AC = 0
  VDD_STEP = 0
  VIN_AC = 1
  VIN_DC = 0.9
  VIN_STEP = 0
  Vsupply = 1.8
