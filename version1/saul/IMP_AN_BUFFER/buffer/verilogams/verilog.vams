//Verilog-AMS HDL for "IMP_AN_BUFFER", "buffer" "verilogams"

`include "constants.vams"
`include "disciplines.vams"

module buffer ( OUT, IN, bias_in, vdda, vssa, vsub );

  input vsub;
  output OUT;
  input vdda;
  input bias_in;
  input vssa;
  input IN;

  electrical IN, OUT, vssa;

  analog begin

  V(OUT,vssa) <+ V(IN,vssa);

  end

endmodule
