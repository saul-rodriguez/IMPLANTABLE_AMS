ADE simulation setup
Run mode: Single Run, Sweeps and Corners
Tests:
  IMP_DIG_SPI:bravo_tb:1: IMP_DIG_SPI/bravo_tb/config, simulator ams
