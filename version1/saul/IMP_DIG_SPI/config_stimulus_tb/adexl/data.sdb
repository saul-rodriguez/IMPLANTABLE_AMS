ADE simulation setup
Run mode: Single Run, Sweeps and Corners
Tests:
  IMP_DIG_SPI:config_stimulus_tb:1: IMP_DIG_SPI/config_stimulus_tb/config, simulator ams
