ADE simulation setup
Run mode: Single Run, Sweeps and Corners
Tests:
  IMP_DIG_SPI:bravo_vm:1: IMP_DIG_SPI/bravo_vm/config, simulator ams
