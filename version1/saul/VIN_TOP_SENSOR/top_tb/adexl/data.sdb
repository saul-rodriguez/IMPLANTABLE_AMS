ADE simulation setup
Run mode: Single Run, Sweeps and Corners
Tests:
  VIN_TOP_SENSOR:top_tb:1: VIN_TOP_SENSOR/top_tb/config, simulator ams
    Outputs: VDUT; VOUT; I; Q; AMP_V; PHA
Global variables:
  CAP_OFF = 0.5n
  CAP_OFF2 = 1n
  CAP_TIA = 4.7n
  CAP_TIA2 = 10.3n
  RL = 500
  CAP_PAD = 700f
