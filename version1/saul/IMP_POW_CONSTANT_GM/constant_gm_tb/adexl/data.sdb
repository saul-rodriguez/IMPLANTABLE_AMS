ADE simulation setup
Run mode: Monte Carlo Sampling
Tests:
  IMP_POW_CONSTANT_GM:constant_gm_tb:1: IMP_POW_CONSTANT_GM/constant_gm_tb/schematic, simulator spectre
Global variables:
  Vsupply = 0
  VD_PULSE = 1.8
Corners (all switched off):
  model folders: /afs/ict.kth.se/proj/ektlab/PDK/AMS/spectre/h18/soac
  C0: mcparams.scs, design.scs[noitm], res.scs[reswp resws], cap.scs[capwp capws], bip.scs[biptm], esddi.scs[esdditm], cmos53.scs[cmoswo cmoswz cmosfff cmosssf]
Monte Carlo Sampling options: mcmethod=all, mcnumpoints=200
