ADE simulation setup
Run mode: Monte Carlo Sampling
Tests:
  IMP_AN_LPF:lpf_tb:1 (off): IMP_AN_LPF/lpf_tb/config, simulator spectre
    Outputs: tran noise; deriv(VS("/VOUT")); offset; vref_cmfb
  tran_noise (off): IMP_AN_LPF/lpf_tb/config, simulator spectre
    Outputs: tran noise
  psrr: IMP_AN_LPF/lpf_tb/config, simulator spectre
    Outputs: tran noise; deriv(VS("/VOUT")); offset; vref_cmfb
Global variables:
  DC_IN = 0
  VDC_CM = 900m
  Vsupply = 1.8
  VIN_PULSE = 0
  VDD_PULSE = 20m
  VDD_AC = 1
  VIN_AC = 0
Corners:
  model folders: /pkg/AMS/spectre/h18/soac
  every corner: /pkg/AMS/spectre/h18/soac/design.scs[noitm], /pkg/AMS/spectre/h18/soac/esddi.scs[esdditm], /pkg/AMS/spectre/h18/soac/bip.scs[biptm], /pkg/AMS/spectre/h18/soac/mcparams.scs
  corner_0 (off): Vsupply=1.62; cap.scs[capwp], res.scs[reswp], cmos53.scs[cmosfff]
  corner_1 (off): Vsupply=1.98; cap.scs[capwp], res.scs[reswp], cmos53.scs[cmosfff]
  corner_2 (off): Vsupply=1.62; cap.scs[capws], res.scs[reswp], cmos53.scs[cmosfff]
  corner_3 (off): Vsupply=1.98; cap.scs[capws], res.scs[reswp], cmos53.scs[cmosfff]
  corner_4 (off): Vsupply=1.62; cap.scs[capwp], res.scs[resws], cmos53.scs[cmosfff]
  corner_5 (off): Vsupply=1.98; cap.scs[capwp], res.scs[resws], cmos53.scs[cmosfff]
  corner_6 (off): Vsupply=1.62; cap.scs[capws], res.scs[resws], cmos53.scs[cmosfff]
  corner_7 (off): Vsupply=1.98; cap.scs[capws], res.scs[resws], cmos53.scs[cmosfff]
  corner_8 (off): Vsupply=1.62; cap.scs[capwp], res.scs[reswp], cmos53.scs[cmosssf]
  corner_9 (off): Vsupply=1.98; cap.scs[capwp], res.scs[reswp], cmos53.scs[cmosssf]
  corner_10 (off): Vsupply=1.62; cap.scs[capws], res.scs[reswp], cmos53.scs[cmosssf]
  corner_11 (off): Vsupply=1.98; cap.scs[capws], res.scs[reswp], cmos53.scs[cmosssf]
  corner_12 (off): Vsupply=1.62; cap.scs[capwp], res.scs[resws], cmos53.scs[cmosssf]
  corner_13 (off): Vsupply=1.98; cap.scs[capwp], res.scs[resws], cmos53.scs[cmosssf]
  corner_14 (off): Vsupply=1.62; cap.scs[capws], res.scs[resws], cmos53.scs[cmosssf]
  corner_15 (off): Vsupply=1.98; cap.scs[capws], res.scs[resws], cmos53.scs[cmosssf]
  corner_16 (off): Vsupply=1.62; cap.scs[capwp], res.scs[reswp], cmos53.scs[cmoswo]
  corner_17 (off): Vsupply=1.98; cap.scs[capwp], res.scs[reswp], cmos53.scs[cmoswo]
  corner_18 (off): Vsupply=1.62; cap.scs[capws], res.scs[reswp], cmos53.scs[cmoswo]
  corner_19 (off): Vsupply=1.98; cap.scs[capws], res.scs[reswp], cmos53.scs[cmoswo]
  corner_20 (off): Vsupply=1.62; cap.scs[capwp], res.scs[resws], cmos53.scs[cmoswo]
  corner_21 (off): Vsupply=1.98; cap.scs[capwp], res.scs[resws], cmos53.scs[cmoswo]
  corner_22 (off): Vsupply=1.62; cap.scs[capws], res.scs[resws], cmos53.scs[cmoswo]
  corner_23 (off): Vsupply=1.98; cap.scs[capws], res.scs[resws], cmos53.scs[cmoswo]
  corner_24 (off): Vsupply=1.62; cap.scs[capwp], res.scs[reswp], cmos53.scs[cmoswz]
  corner_25 (off): Vsupply=1.98; cap.scs[capwp], res.scs[reswp], cmos53.scs[cmoswz]
  corner_26 (off): Vsupply=1.62; cap.scs[capws], res.scs[reswp], cmos53.scs[cmoswz]
  corner_27 (off): Vsupply=1.98; cap.scs[capws], res.scs[reswp], cmos53.scs[cmoswz]
  corner_28 (off): Vsupply=1.62; cap.scs[capwp], res.scs[resws], cmos53.scs[cmoswz]
  corner_29 (off): Vsupply=1.98; cap.scs[capwp], res.scs[resws], cmos53.scs[cmoswz]
  corner_30 (off): Vsupply=1.62; cap.scs[capws], res.scs[resws], cmos53.scs[cmoswz]
  corner_31 (off): Vsupply=1.98; cap.scs[capws], res.scs[resws], cmos53.scs[cmoswz]
Monte Carlo Sampling options: mcmethod=all, mcnumpoints=200
