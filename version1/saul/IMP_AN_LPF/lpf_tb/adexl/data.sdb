ADE simulation setup
Run mode: Single Run, Sweeps and Corners
Tests:
  IMP_AN_LPF:lpf_tb:1 (off): IMP_AN_LPF/lpf_tb/config, simulator spectre
    Outputs: tran noise; deriv(VS("/VOUT")); offset; vref_cmfb; dB20(VF("/VOUT")); pssr_10; value(dB20(VF("/VOUT")) 10); pssr_100; pssr_1000; psss_10k
  tran_noise (off): IMP_AN_LPF/lpf_tb/config, simulator spectre
    Outputs: tran noise
  psrr (off): IMP_AN_LPF/lpf_tb/config, simulator spectre
    Outputs: tran noise; deriv(VS("/VOUT")); offset; vref_cmfb
  IMP_AN_LPF:lpf_tb:2 (off): IMP_AN_LPF/lpf_tb/config, simulator spectre
  IMP_AN_LPF:lpf_tb:3: IMP_AN_LPF/lpf_tb/config, simulator spectre
Global variables:
  DC_IN = 0
  VDC_CM = 900m
  Vsupply = 1.8
  VIN_PULSE = 0
  VDD_PULSE = 0
  VDD_AC = 0
  VIN_AC = 1
  CAP_FIL = 1.5n
  VCM_PULSE = 0
Corners (all switched off):
  model folders: /pkg/AMS/spectre/h18/soac
  every corner: /pkg/AMS/spectre/h18/soac/design.scs[noitm], /pkg/AMS/spectre/h18/soac/esddi.scs[esdditm], /pkg/AMS/spectre/h18/soac/bip.scs[biptm], /pkg/AMS/spectre/h18/soac/mcparams.scs
  corner_0: Vsupply=1.62; cap.scs[capwp], res.scs[reswp], cmos53.scs[cmosfff]
  corner_1: Vsupply=1.98; cap.scs[capwp], res.scs[reswp], cmos53.scs[cmosfff]
  corner_2: Vsupply=1.62; cap.scs[capws], res.scs[reswp], cmos53.scs[cmosfff]
  corner_3: Vsupply=1.98; cap.scs[capws], res.scs[reswp], cmos53.scs[cmosfff]
  corner_4: Vsupply=1.62; cap.scs[capwp], res.scs[resws], cmos53.scs[cmosfff]
  corner_5: Vsupply=1.98; cap.scs[capwp], res.scs[resws], cmos53.scs[cmosfff]
  corner_6: Vsupply=1.62; cap.scs[capws], res.scs[resws], cmos53.scs[cmosfff]
  corner_7: Vsupply=1.98; cap.scs[capws], res.scs[resws], cmos53.scs[cmosfff]
  corner_8: Vsupply=1.62; cap.scs[capwp], res.scs[reswp], cmos53.scs[cmosssf]
  corner_9: Vsupply=1.98; cap.scs[capwp], res.scs[reswp], cmos53.scs[cmosssf]
  corner_10: Vsupply=1.62; cap.scs[capws], res.scs[reswp], cmos53.scs[cmosssf]
  corner_11: Vsupply=1.98; cap.scs[capws], res.scs[reswp], cmos53.scs[cmosssf]
  corner_12: Vsupply=1.62; cap.scs[capwp], res.scs[resws], cmos53.scs[cmosssf]
  corner_13: Vsupply=1.98; cap.scs[capwp], res.scs[resws], cmos53.scs[cmosssf]
  corner_14: Vsupply=1.62; cap.scs[capws], res.scs[resws], cmos53.scs[cmosssf]
  corner_15: Vsupply=1.98; cap.scs[capws], res.scs[resws], cmos53.scs[cmosssf]
  corner_16: Vsupply=1.62; cap.scs[capwp], res.scs[reswp], cmos53.scs[cmoswo]
  corner_17: Vsupply=1.98; cap.scs[capwp], res.scs[reswp], cmos53.scs[cmoswo]
  corner_18: Vsupply=1.62; cap.scs[capws], res.scs[reswp], cmos53.scs[cmoswo]
  corner_19: Vsupply=1.98; cap.scs[capws], res.scs[reswp], cmos53.scs[cmoswo]
  corner_20: Vsupply=1.62; cap.scs[capwp], res.scs[resws], cmos53.scs[cmoswo]
  corner_21: Vsupply=1.98; cap.scs[capwp], res.scs[resws], cmos53.scs[cmoswo]
  corner_22: Vsupply=1.62; cap.scs[capws], res.scs[resws], cmos53.scs[cmoswo]
  corner_23: Vsupply=1.98; cap.scs[capws], res.scs[resws], cmos53.scs[cmoswo]
  corner_24: Vsupply=1.62; cap.scs[capwp], res.scs[reswp], cmos53.scs[cmoswz]
  corner_25: Vsupply=1.98; cap.scs[capwp], res.scs[reswp], cmos53.scs[cmoswz]
  corner_26: Vsupply=1.62; cap.scs[capws], res.scs[reswp], cmos53.scs[cmoswz]
  corner_27: Vsupply=1.98; cap.scs[capws], res.scs[reswp], cmos53.scs[cmoswz]
  corner_28: Vsupply=1.62; cap.scs[capwp], res.scs[resws], cmos53.scs[cmoswz]
  corner_29: Vsupply=1.98; cap.scs[capwp], res.scs[resws], cmos53.scs[cmoswz]
  corner_30: Vsupply=1.62; cap.scs[capws], res.scs[resws], cmos53.scs[cmoswz]
  corner_31: Vsupply=1.98; cap.scs[capws], res.scs[resws], cmos53.scs[cmoswz]
