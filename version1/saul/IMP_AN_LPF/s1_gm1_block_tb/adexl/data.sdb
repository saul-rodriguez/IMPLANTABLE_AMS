ADE simulation setup
Run mode: Single Run, Sweeps and Corners
Tests:
  IMP_AN_LPF:s1_gm1_block_tb:1: IMP_AN_LPF/s1_gm1_block_tb/schematic, simulator spectre
Global variables:
  DC_IN = 1
  VDC_CM = 900m
  Vsupply = 1.8
Corners (nominal off):
  model folders: /pkg/AMS/spectre/h18/soac
  every corner: /pkg/AMS/spectre/h18/soac/design.scs[noitm], /pkg/AMS/spectre/h18/soac/esddi.scs[esdditm], /pkg/AMS/spectre/h18/soac/bip.scs[biptm], /pkg/AMS/spectre/h18/soac/mcparams.scs
  corner_0 (off): Vsupply=1.62; cap.scs[capwp], res.scs[reswp], cmos53.scs[cmosfff]
  corner_1 (off): Vsupply=1.98; cap.scs[capwp], res.scs[reswp], cmos53.scs[cmosfff]
  corner_2 (off): Vsupply=1.62; cap.scs[capws], res.scs[reswp], cmos53.scs[cmosfff]
  corner_3 (off): Vsupply=1.98; cap.scs[capws], res.scs[reswp], cmos53.scs[cmosfff]
  corner_4 (off): Vsupply=1.62; cap.scs[capwp], res.scs[resws], cmos53.scs[cmosfff]
  corner_5 (off): Vsupply=1.98; cap.scs[capwp], res.scs[resws], cmos53.scs[cmosfff]
  corner_6 (off): Vsupply=1.62; cap.scs[capws], res.scs[resws], cmos53.scs[cmosfff]
  corner_7 (off): Vsupply=1.98; cap.scs[capws], res.scs[resws], cmos53.scs[cmosfff]
  corner_8: Vsupply=1.62; cap.scs[capwp], res.scs[reswp], cmos53.scs[cmosssf]
  corner_9 (off): Vsupply=1.98; cap.scs[capwp], res.scs[reswp], cmos53.scs[cmosssf]
  corner_10 (off): Vsupply=1.62; cap.scs[capws], res.scs[reswp], cmos53.scs[cmosssf]
  corner_11 (off): Vsupply=1.98; cap.scs[capws], res.scs[reswp], cmos53.scs[cmosssf]
  corner_12 (off): Vsupply=1.62; cap.scs[capwp], res.scs[resws], cmos53.scs[cmosssf]
  corner_13 (off): Vsupply=1.98; cap.scs[capwp], res.scs[resws], cmos53.scs[cmosssf]
  corner_14 (off): Vsupply=1.62; cap.scs[capws], res.scs[resws], cmos53.scs[cmosssf]
  corner_15 (off): Vsupply=1.98; cap.scs[capws], res.scs[resws], cmos53.scs[cmosssf]
  corner_16 (off): Vsupply=1.62; cap.scs[capwp], res.scs[reswp], cmos53.scs[cmoswo]
  corner_17 (off): Vsupply=1.98; cap.scs[capwp], res.scs[reswp], cmos53.scs[cmoswo]
  corner_18 (off): Vsupply=1.62; cap.scs[capws], res.scs[reswp], cmos53.scs[cmoswo]
  corner_19 (off): Vsupply=1.98; cap.scs[capws], res.scs[reswp], cmos53.scs[cmoswo]
  corner_20 (off): Vsupply=1.62; cap.scs[capwp], res.scs[resws], cmos53.scs[cmoswo]
  corner_21 (off): Vsupply=1.98; cap.scs[capwp], res.scs[resws], cmos53.scs[cmoswo]
  corner_22 (off): Vsupply=1.62; cap.scs[capws], res.scs[resws], cmos53.scs[cmoswo]
  corner_23 (off): Vsupply=1.98; cap.scs[capws], res.scs[resws], cmos53.scs[cmoswo]
  corner_24 (off): Vsupply=1.62; cap.scs[capwp], res.scs[reswp], cmos53.scs[cmoswz]
  corner_25 (off): Vsupply=1.98; cap.scs[capwp], res.scs[reswp], cmos53.scs[cmoswz]
  corner_26 (off): Vsupply=1.62; cap.scs[capws], res.scs[reswp], cmos53.scs[cmoswz]
  corner_27 (off): Vsupply=1.98; cap.scs[capws], res.scs[reswp], cmos53.scs[cmoswz]
  corner_28 (off): Vsupply=1.62; cap.scs[capwp], res.scs[resws], cmos53.scs[cmoswz]
  corner_29 (off): Vsupply=1.98; cap.scs[capwp], res.scs[resws], cmos53.scs[cmoswz]
  corner_30 (off): Vsupply=1.62; cap.scs[capws], res.scs[resws], cmos53.scs[cmoswz]
  corner_31 (off): Vsupply=1.98; cap.scs[capws], res.scs[resws], cmos53.scs[cmoswz]
