//Verilog-AMS HDL for "IMP_PLL_TOP", "PLL_top_tb" "verilogams"

`include "constants.vams"
`include "disciplines.vams"
`timescale 1ns / 1ps

//real next;

module PLL_top_stimulus(Fin,FSel,Resetn);

output Fin;
output [3:0] FSel;
output Resetn;

parameter cycle = 2000;
parameter [3:0] freq_selection = 0'b0000;

reg Fin;
reg Resetn;
reg [3:0] FSel;

initial begin
	Fin = 0;
	Resetn = 1;
	FSel = freq_selection;

	#200 Resetn = 0;
	#200 Resetn = 1;
end

always #(cycle/2) Fin = ~Fin;

endmodule
