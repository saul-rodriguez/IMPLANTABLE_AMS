ADE simulation setup
Run mode: Single Run, Sweeps and Corners
Tests:
  IMP_PLL_TOP:PLL_top_tb_spectre:1: IMP_PLL_TOP/PLL_top_tb_spectre/config, simulator spectre
Global variables:
  FREQ = 500k
  Vsupply = 1.8
  fmax = 40M
