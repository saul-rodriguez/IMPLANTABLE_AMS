ADE simulation setup
Run mode: Single Run, Sweeps and Corners
Tests:
  IMP_PLL_TOP:PLL_top_tb:1: IMP_PLL_TOP/PLL_top_tb/config, simulator ams
Global variables:
  MYFREQ = 5
  Vsupply = 1.8
  fmax = 37.5M
Corners:
  model folders: /pkg/AMS411/spectre/h18
  every corner: /pkg/AMS411/spectre/h18/mcparams.scs, /pkg/AMS411/spectre/h18/design.scs[noitm], /pkg/AMS411/spectre/h18/bip.scs[biptm], /pkg/AMS411/spectre/h18/esddi.scs[esdditm]
  C2_0: res.scs[reswp], cap.scs[capwp], cmos53.scs[cmosfff]
  C2_1: res.scs[resws], cap.scs[capwp], cmos53.scs[cmosfff]
  C2_2: res.scs[reswp], cap.scs[capws], cmos53.scs[cmosfff]
  C2_3: res.scs[resws], cap.scs[capws], cmos53.scs[cmosfff]
  C2_4: res.scs[reswp], cap.scs[capwp], cmos53.scs[cmosssf]
  C2_5: res.scs[resws], cap.scs[capwp], cmos53.scs[cmosssf]
  C2_6: res.scs[reswp], cap.scs[capws], cmos53.scs[cmosssf]
  C2_7: res.scs[resws], cap.scs[capws], cmos53.scs[cmosssf]
  C2_8: res.scs[reswp], cap.scs[capwp], cmos53.scs[cmoswo]
  C2_9: res.scs[resws], cap.scs[capwp], cmos53.scs[cmoswo]
  C2_10: res.scs[reswp], cap.scs[capws], cmos53.scs[cmoswo]
  C2_11: res.scs[resws], cap.scs[capws], cmos53.scs[cmoswo]
  C2_12: res.scs[reswp], cap.scs[capwp], cmos53.scs[cmoswz]
  C2_13: res.scs[resws], cap.scs[capwp], cmos53.scs[cmoswz]
  C2_14: res.scs[reswp], cap.scs[capws], cmos53.scs[cmoswz]
  C2_15: res.scs[resws], cap.scs[capws], cmos53.scs[cmoswz]
