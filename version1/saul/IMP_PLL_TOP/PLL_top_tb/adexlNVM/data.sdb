ADE simulation setup
Run mode: Single Run, Sweeps and Corners
Tests:
  IMP_PLL_TOP:PLL_top_tb:1: IMP_PLL_TOP/PLL_top_tb/config, simulator ams
Global variables:
  MYFREQ = 5
Corners:
  model folders: /pkg/AMS411/spectre/h18/soac
  every corner: /pkg/AMS411/spectre/h18/soac/mcparams.scs, /pkg/AMS411/spectre/h18/soac/design.scs[noitm], /pkg/AMS411/spectre/h18/soac/bip.scs[biptm], /pkg/AMS411/spectre/h18/soac/esddi.scs[esdditm]
  C1_0: res.scs[reswp], cap.scs[capwp], cmos53.scs[cmosfff]
  C1_1: res.scs[resws], cap.scs[capwp], cmos53.scs[cmosfff]
  C1_2: res.scs[reswp], cap.scs[capws], cmos53.scs[cmosfff]
  C1_3: res.scs[resws], cap.scs[capws], cmos53.scs[cmosfff]
  C1_4: res.scs[reswp], cap.scs[capwp], cmos53.scs[cmosssf]
  C1_5: res.scs[resws], cap.scs[capwp], cmos53.scs[cmosssf]
  C1_6: res.scs[reswp], cap.scs[capws], cmos53.scs[cmosssf]
  C1_7: res.scs[resws], cap.scs[capws], cmos53.scs[cmosssf]
  C1_8: res.scs[reswp], cap.scs[capwp], cmos53.scs[cmoswo]
  C1_9: res.scs[resws], cap.scs[capwp], cmos53.scs[cmoswo]
  C1_10: res.scs[reswp], cap.scs[capws], cmos53.scs[cmoswo]
  C1_11: res.scs[resws], cap.scs[capws], cmos53.scs[cmoswo]
  C1_12: res.scs[reswp], cap.scs[capwp], cmos53.scs[cmoswz]
  C1_13: res.scs[resws], cap.scs[capwp], cmos53.scs[cmoswz]
  C1_14: res.scs[reswp], cap.scs[capws], cmos53.scs[cmoswz]
  C1_15: res.scs[resws], cap.scs[capws], cmos53.scs[cmoswz]
