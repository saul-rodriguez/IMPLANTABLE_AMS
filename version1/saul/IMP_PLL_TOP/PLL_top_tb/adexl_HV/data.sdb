ADE simulation setup
Run mode: Single Run, Sweeps and Corners
Tests:
  IMP_PLL_TOP:PLL_top_tb:1: IMP_PLL_TOP/PLL_top_tb/config, simulator ams
Global variables:
  fmax = 60M
  Vsupply = 1.8
