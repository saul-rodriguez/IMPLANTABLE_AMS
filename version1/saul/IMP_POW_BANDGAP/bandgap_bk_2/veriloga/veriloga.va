// VerilogA for IMP_POW_BANDGAP, bandgap, veriloga

`include "constants.vams"
`include "disciplines.vams"

module bandgap(V_REF, bias, vdda, vssa, vsub);
output V_REF;
electrical V_REF;
input bias;
electrical bias;
input vdda;
electrical vdda;
input vssa;
electrical vssa;
input vsub;
electrical vsub;

analog begin

	if (V(vdda) > 1.25) begin
		V(V_REF) <+ 1.25;
	end else begin
		V(V_REF) <+ V(vdda);
	end

	V(bias) <+ I(bias)*1;

end

endmodule
