ADE simulation setup
Run mode: Monte Carlo Sampling
Tests:
  IMP_POW_BANDGAP:bandgap_tb:1: IMP_POW_BANDGAP/bandgap_tb/schematic, simulator spectre
    Outputs: VDC("/VREF")
Global variables:
  VD_PULSE = 1.8
  Vsupply = 1.8
  VIN_AC = 0
  IBIAS = 100n
  VD_AC = 1
  R1 = 250k
  R3 = 30K
  CL = 0.1p
  RL = 100M
  IBIAS_STEP = 0
  VD_RISE = 500u
Corners (all switched off):
  model folders: /afs/ict.kth.se/proj/ektlab/PDK/AMS/spectre/h18/soac
  every corner: /afs/ict.kth.se/proj/ektlab/PDK/AMS/spectre/h18/soac/design.scs[noitm], /afs/ict.kth.se/proj/ektlab/PDK/AMS/spectre/h18/soac/esddi.scs[esdditm], /afs/ict.kth.se/proj/ektlab/PDK/AMS/spectre/h18/soac/bip.scs[biptm], /afs/ict.kth.se/proj/ektlab/PDK/AMS/spectre/h18/mcparams.scs
  corner_0: temperature=27; Vsupply=1.62; cap.scs[capwp], res.scs[reswp], cmos53.scs[cmosfff]
  corner_1: temperature=27; Vsupply=1.98; cap.scs[capwp], res.scs[reswp], cmos53.scs[cmosfff]
  corner_2: temperature=27; Vsupply=1.62; cap.scs[capws], res.scs[reswp], cmos53.scs[cmosfff]
  corner_3: temperature=27; Vsupply=1.98; cap.scs[capws], res.scs[reswp], cmos53.scs[cmosfff]
  corner_4: temperature=27; Vsupply=1.62; cap.scs[capwp], res.scs[resws], cmos53.scs[cmosfff]
  corner_5: temperature=27; Vsupply=1.98; cap.scs[capwp], res.scs[resws], cmos53.scs[cmosfff]
  corner_6: temperature=27; Vsupply=1.62; cap.scs[capws], res.scs[resws], cmos53.scs[cmosfff]
  corner_7: temperature=27; Vsupply=1.98; cap.scs[capws], res.scs[resws], cmos53.scs[cmosfff]
  corner_8: temperature=27; Vsupply=1.62; cap.scs[capwp], res.scs[reswp], cmos53.scs[cmosssf]
  corner_9: temperature=27; Vsupply=1.98; cap.scs[capwp], res.scs[reswp], cmos53.scs[cmosssf]
  corner_10: temperature=27; Vsupply=1.62; cap.scs[capws], res.scs[reswp], cmos53.scs[cmosssf]
  corner_11: temperature=27; Vsupply=1.98; cap.scs[capws], res.scs[reswp], cmos53.scs[cmosssf]
  corner_12: temperature=27; Vsupply=1.62; cap.scs[capwp], res.scs[resws], cmos53.scs[cmosssf]
  corner_13: temperature=27; Vsupply=1.98; cap.scs[capwp], res.scs[resws], cmos53.scs[cmosssf]
  corner_14: temperature=27; Vsupply=1.62; cap.scs[capws], res.scs[resws], cmos53.scs[cmosssf]
  corner_15: temperature=27; Vsupply=1.98; cap.scs[capws], res.scs[resws], cmos53.scs[cmosssf]
  corner_16: temperature=27; Vsupply=1.62; cap.scs[capwp], res.scs[reswp], cmos53.scs[cmoswo]
  corner_17: temperature=27; Vsupply=1.98; cap.scs[capwp], res.scs[reswp], cmos53.scs[cmoswo]
  corner_18: temperature=27; Vsupply=1.62; cap.scs[capws], res.scs[reswp], cmos53.scs[cmoswo]
  corner_19: temperature=27; Vsupply=1.98; cap.scs[capws], res.scs[reswp], cmos53.scs[cmoswo]
  corner_20: temperature=27; Vsupply=1.62; cap.scs[capwp], res.scs[resws], cmos53.scs[cmoswo]
  corner_21: temperature=27; Vsupply=1.98; cap.scs[capwp], res.scs[resws], cmos53.scs[cmoswo]
  corner_22: temperature=27; Vsupply=1.62; cap.scs[capws], res.scs[resws], cmos53.scs[cmoswo]
  corner_23: temperature=27; Vsupply=1.98; cap.scs[capws], res.scs[resws], cmos53.scs[cmoswo]
  corner_24: temperature=27; Vsupply=1.62; cap.scs[capwp], res.scs[reswp], cmos53.scs[cmoswz]
  corner_25: temperature=27; Vsupply=1.98; cap.scs[capwp], res.scs[reswp], cmos53.scs[cmoswz]
  corner_26: temperature=27; Vsupply=1.62; cap.scs[capws], res.scs[reswp], cmos53.scs[cmoswz]
  corner_27: temperature=27; Vsupply=1.98; cap.scs[capws], res.scs[reswp], cmos53.scs[cmoswz]
  corner_28: temperature=27; Vsupply=1.62; cap.scs[capwp], res.scs[resws], cmos53.scs[cmoswz]
  corner_29: temperature=27; Vsupply=1.98; cap.scs[capwp], res.scs[resws], cmos53.scs[cmoswz]
  corner_30: temperature=27; Vsupply=1.62; cap.scs[capws], res.scs[resws], cmos53.scs[cmoswz]
  corner_31: temperature=27; Vsupply=1.98; cap.scs[capws], res.scs[resws], cmos53.scs[cmoswz]
Monte Carlo Sampling options: mcmethod=all, mcnumpoints=200
