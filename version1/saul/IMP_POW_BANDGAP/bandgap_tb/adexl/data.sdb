ADE simulation setup
Run mode: Single Run, Sweeps and Corners
Tests:
  IMP_POW_BANDGAP:bandgap_tb:1: IMP_POW_BANDGAP/bandgap_tb/config, simulator spectre
Global variables:
  CL = 200f
  IBIAS = 100n
  IBIAS_STEP = 0
  RL = 10M
  VD_AC = 1
  VD_PULSE = 100m
  VD_RISE = 1n
  Vsupply = 1.8
